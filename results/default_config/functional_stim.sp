* Functional test stimulus file for 10ns period

* TT process corner
.include "/Users/stanlee/OpenRAM/technology/scn4m_subm/models/nom/pmos.sp"
.include "/Users/stanlee/OpenRAM/technology/scn4m_subm/models/nom/nmos.sp"
.include "/tmp/openram_stanlee_5553_temp/sram.sp"

* Global Power Supplies
Vvdd vdd 0 3.3

*Nodes gnd and 0 are the same global ground node in ngspice/hspice/xa. Otherwise, this source may be needed.
*Vgnd gnd 0 0.0

* Instantiation of the SRAM
Xsram_16x2 din0_0 din0_1 a0_0 a0_1 a0_2 a0_3 CSB0 WEB0 clk0 dout0_0 dout0_1 vdd gnd sram_16x2

* SRAM output loads
CD00 dout0_0  0 39.2968f
CD01 dout0_1  0 39.2968f

* Important signals for debug
* bl:	xsram:xbank0:bl_0_0
* br:	xsram:xbank0:br_0_0
* s_en:	xsram:s_en
* q:	xsram:xbank0:xbitcell_array:xbitcell_array:xbit_r0_c0.Q
* qbar:	xsram:xbank0:xbitcell_array:xbitcell_array:xbit_r0_c0.Q_bar

* Sequence of operations
*	Idle during cycle 0 (0ns - 10ns)
*	Writing 11  to  address 1110 (from port 0) during cycle 1 (10ns - 20ns)
*	Writing 01  to  address 1110 (from port 0) during cycle 2 (20ns - 30ns)
*	Writing 10  to  address 1110 (from port 0) during cycle 3 (30ns - 40ns)
*	Reading 10 from address 1110 (from port 0) during cycle 4 (40ns - 50ns)
*	Writing 01  to  address 1110 (from port 0) during cycle 5 (50ns - 60ns)
*	Reading 01 from address 1110 (from port 0) during cycle 7 (70ns - 80ns)
*	Reading 01 from address 1110 (from port 0) during cycle 8 (80ns - 90ns)
*	Writing 11  to  address 1110 (from port 0) during cycle 9 (90ns - 100ns)
*	Reading 11 from address 1110 (from port 0) during cycle 10 (100ns - 110ns)
*	Reading 11 from address 1110 (from port 0) during cycle 11 (110ns - 120ns)
*	Writing 01  to  address 1110 (from port 0) during cycle 12 (120ns - 130ns)
*	Reading 01 from address 1110 (from port 0) during cycle 13 (130ns - 140ns)
*	Reading 01 from address 1110 (from port 0) during cycle 14 (140ns - 150ns)
*	Writing 11  to  address 1110 (from port 0) during cycle 16 (160ns - 170ns)
*	Reading 11 from address 1110 (from port 0) during cycle 17 (170ns - 180ns)
*	Writing 01  to  address 0000 (from port 0) during cycle 18 (180ns - 190ns)
*	Reading 01 from address 0000 (from port 0) during cycle 19 (190ns - 200ns)
*	Reading 11 from address 1110 (from port 0) during cycle 20 (200ns - 210ns)
*	Reading 01 from address 0000 (from port 0) during cycle 21 (210ns - 220ns)
*	Reading 11 from address 1110 (from port 0) during cycle 22 (220ns - 230ns)
*	Writing 10  to  address 0000 (from port 0) during cycle 24 (240ns - 250ns)
*	Writing 10  to  address 1110 (from port 0) during cycle 25 (250ns - 260ns)
*	Reading 10 from address 1110 (from port 0) during cycle 26 (260ns - 270ns)
*	Reading 10 from address 1110 (from port 0) during cycle 28 (280ns - 290ns)
*	Reading 10 from address 1110 (from port 0) during cycle 30 (300ns - 310ns)
*	Writing 11  to  address 1110 (from port 0) during cycle 31 (310ns - 320ns)
*	Reading 10 from address 0000 (from port 0) during cycle 32 (320ns - 330ns)
*	Reading 11 from address 1110 (from port 0) during cycle 33 (330ns - 340ns)
*	Reading 11 from address 1110 (from port 0) during cycle 35 (350ns - 360ns)
*	Reading 10 from address 0000 (from port 0) during cycle 36 (360ns - 370ns)
*	Writing 10  to  address 0000 (from port 0) during cycle 38 (380ns - 390ns)
*	Writing 01  to  address 1110 (from port 0) during cycle 39 (390ns - 400ns)
*	Reading 10 from address 0000 (from port 0) during cycle 40 (400ns - 410ns)
*	Writing 01  to  address 1110 (from port 0) during cycle 42 (420ns - 430ns)
*	Reading 10 from address 0000 (from port 0) during cycle 45 (450ns - 460ns)
*	Reading 01 from address 1110 (from port 0) during cycle 46 (460ns - 470ns)
*	Reading 10 from address 0000 (from port 0) during cycle 47 (470ns - 480ns)
*	Reading 10 from address 0000 (from port 0) during cycle 48 (480ns - 490ns)
*	Reading 01 from address 1110 (from port 0) during cycle 49 (490ns - 500ns)
*	Reading 10 from address 0000 (from port 0) during cycle 50 (500ns - 510ns)
*	Reading 10 from address 0000 (from port 0) during cycle 52 (520ns - 530ns)
*	Reading 10 from address 0000 (from port 0) during cycle 53 (530ns - 540ns)
*	Writing 11  to  address 0000 (from port 0) during cycle 54 (540ns - 550ns)
*	Writing 10  to  address 0000 (from port 0) during cycle 55 (550ns - 560ns)
*	Writing 01  to  address 0000 (from port 0) during cycle 58 (580ns - 590ns)
*	Writing 10  to  address 1110 (from port 0) during cycle 59 (590ns - 600ns)
*	Writing 10  to  address 0000 (from port 0) during cycle 60 (600ns - 610ns)
*	Writing 10  to  address 1110 (from port 0) during cycle 61 (610ns - 620ns)
*	Reading 10 from address 1110 (from port 0) during cycle 65 (650ns - 660ns)
*	Reading 10 from address 1110 (from port 0) during cycle 66 (660ns - 670ns)
*	Writing 11  to  address 1110 (from port 0) during cycle 69 (690ns - 700ns)
*	Writing 11  to  address 1110 (from port 0) during cycle 70 (700ns - 710ns)
*	Reading 10 from address 0000 (from port 0) during cycle 71 (710ns - 720ns)
*	Reading 10 from address 0000 (from port 0) during cycle 73 (730ns - 740ns)
*	Reading 11 from address 1110 (from port 0) during cycle 74 (740ns - 750ns)
*	Reading 11 from address 1110 (from port 0) during cycle 75 (750ns - 760ns)
*	Reading 10 from address 0000 (from port 0) during cycle 76 (760ns - 770ns)
*	Writing 10  to  address 0000 (from port 0) during cycle 79 (790ns - 800ns)
*	Writing 11  to  address 0000 (from port 0) during cycle 80 (800ns - 810ns)
*	Reading 11 from address 1110 (from port 0) during cycle 81 (810ns - 820ns)
*	Reading 11 from address 1110 (from port 0) during cycle 82 (820ns - 830ns)
*	Reading 11 from address 0000 (from port 0) during cycle 85 (850ns - 860ns)
*	Reading 11 from address 1110 (from port 0) during cycle 86 (860ns - 870ns)
*	Reading 11 from address 1110 (from port 0) during cycle 88 (880ns - 890ns)
*	Reading 11 from address 1110 (from port 0) during cycle 89 (890ns - 900ns)
*	Writing 10  to  address 0000 (from port 0) during cycle 90 (900ns - 910ns)
*	Reading 11 from address 1110 (from port 0) during cycle 92 (920ns - 930ns)
*	Reading 11 from address 1110 (from port 0) during cycle 93 (930ns - 940ns)
*	Reading 11 from address 1110 (from port 0) during cycle 95 (950ns - 960ns)
*	Reading 10 from address 0000 (from port 0) during cycle 96 (960ns - 970ns)
*	Reading 11 from address 1110 (from port 0) during cycle 97 (970ns - 980ns)
*	Writing 01  to  address 1110 (from port 0) during cycle 98 (980ns - 990ns)
*	Reading 01 from address 1110 (from port 0) during cycle 99 (990ns - 1000ns)
*	Writing 10  to  address 0000 (from port 0) during cycle 100 (1000ns - 1010ns)
*	Reading 01 from address 1110 (from port 0) during cycle 101 (1010ns - 1020ns)
*	Writing 11  to  address 1110 (from port 0) during cycle 103 (1030ns - 1040ns)
*	Writing 10  to  address 1110 (from port 0) during cycle 104 (1040ns - 1050ns)
*	Writing 10  to  address 0000 (from port 0) during cycle 106 (1060ns - 1070ns)
*	Reading 10 from address 0000 (from port 0) during cycle 107 (1070ns - 1080ns)
*	Writing 10  to  address 1110 (from port 0) during cycle 108 (1080ns - 1090ns)
*	Reading 10 from address 1110 (from port 0) during cycle 109 (1090ns - 1100ns)
*	Reading 10 from address 0000 (from port 0) during cycle 110 (1100ns - 1110ns)
*	Reading 10 from address 0000 (from port 0) during cycle 111 (1110ns - 1120ns)
*	Writing 11  to  address 0000 (from port 0) during cycle 113 (1130ns - 1140ns)
*	Writing 10  to  address 1110 (from port 0) during cycle 114 (1140ns - 1150ns)
*	Writing 10  to  address 1110 (from port 0) during cycle 115 (1150ns - 1160ns)
*	Writing 01  to  address 1110 (from port 0) during cycle 116 (1160ns - 1170ns)
*	Writing 10  to  address 0000 (from port 0) during cycle 117 (1170ns - 1180ns)
*	Writing 11  to  address 0000 (from port 0) during cycle 118 (1180ns - 1190ns)
*	Reading 01 from address 1110 (from port 0) during cycle 119 (1190ns - 1200ns)
*	Reading 01 from address 1110 (from port 0) during cycle 120 (1200ns - 1210ns)
*	Reading 01 from address 1110 (from port 0) during cycle 121 (1210ns - 1220ns)
*	Reading 11 from address 0000 (from port 0) during cycle 122 (1220ns - 1230ns)
*	Reading 01 from address 1110 (from port 0) during cycle 123 (1230ns - 1240ns)
*	Reading 01 from address 1110 (from port 0) during cycle 125 (1250ns - 1260ns)
*	Reading 11 from address 0000 (from port 0) during cycle 126 (1260ns - 1270ns)
*	Reading 01 from address 1110 (from port 0) during cycle 127 (1270ns - 1280ns)
*	Writing 11  to  address 0000 (from port 0) during cycle 128 (1280ns - 1290ns)
*	Writing 01  to  address 1110 (from port 0) during cycle 130 (1300ns - 1310ns)
*	Reading 11 from address 0000 (from port 0) during cycle 131 (1310ns - 1320ns)
*	Writing 10  to  address 1110 (from port 0) during cycle 133 (1330ns - 1340ns)
*	Writing 10  to  address 1110 (from port 0) during cycle 134 (1340ns - 1350ns)
*	Reading 10 from address 1110 (from port 0) during cycle 135 (1350ns - 1360ns)
*	Reading 11 from address 0000 (from port 0) during cycle 136 (1360ns - 1370ns)
*	Reading 10 from address 1110 (from port 0) during cycle 139 (1390ns - 1400ns)
*	Writing 11  to  address 1110 (from port 0) during cycle 140 (1400ns - 1410ns)
*	Writing 10  to  address 0000 (from port 0) during cycle 141 (1410ns - 1420ns)
*	Writing 01  to  address 1110 (from port 0) during cycle 144 (1440ns - 1450ns)
*	Writing 11  to  address 0000 (from port 0) during cycle 146 (1460ns - 1470ns)
*	Reading 01 from address 1110 (from port 0) during cycle 147 (1470ns - 1480ns)
*	Writing 11  to  address 1110 (from port 0) during cycle 148 (1480ns - 1490ns)
*	Reading 11 from address 0000 (from port 0) during cycle 151 (1510ns - 1520ns)
*	Reading 11 from address 1110 (from port 0) during cycle 152 (1520ns - 1530ns)
*	Reading 11 from address 1110 (from port 0) during cycle 153 (1530ns - 1540ns)
*	Writing 10  to  address 0000 (from port 0) during cycle 154 (1540ns - 1550ns)
*	Writing 10  to  address 0000 (from port 0) during cycle 155 (1550ns - 1560ns)
*	Reading 11 from address 1110 (from port 0) during cycle 156 (1560ns - 1570ns)
*	Reading 10 from address 0000 (from port 0) during cycle 158 (1580ns - 1590ns)
*	Writing 10  to  address 1110 (from port 0) during cycle 160 (1600ns - 1610ns)
*	Reading 10 from address 1110 (from port 0) during cycle 161 (1610ns - 1620ns)
*	Writing 10  to  address 1110 (from port 0) during cycle 162 (1620ns - 1630ns)
*	Reading 10 from address 1110 (from port 0) during cycle 163 (1630ns - 1640ns)
*	Reading 10 from address 1110 (from port 0) during cycle 164 (1640ns - 1650ns)
*	Reading 10 from address 0000 (from port 0) during cycle 165 (1650ns - 1660ns)
*	Writing 01  to  address 0000 (from port 0) during cycle 166 (1660ns - 1670ns)
*	Writing 01  to  address 1110 (from port 0) during cycle 167 (1670ns - 1680ns)
*	Reading 01 from address 1110 (from port 0) during cycle 168 (1680ns - 1690ns)
*	Reading 01 from address 1110 (from port 0) during cycle 169 (1690ns - 1700ns)
*	Reading 01 from address 1110 (from port 0) during cycle 170 (1700ns - 1710ns)
*	Reading 01 from address 1110 (from port 0) during cycle 171 (1710ns - 1720ns)
*	Reading 01 from address 0000 (from port 0) during cycle 172 (1720ns - 1730ns)
*	Reading 01 from address 1110 (from port 0) during cycle 173 (1730ns - 1740ns)
*	Writing 01  to  address 0000 (from port 0) during cycle 174 (1740ns - 1750ns)
*	Reading 01 from address 1110 (from port 0) during cycle 175 (1750ns - 1760ns)
*	Reading 01 from address 1110 (from port 0) during cycle 176 (1760ns - 1770ns)
*	Reading 01 from address 1110 (from port 0) during cycle 179 (1790ns - 1800ns)
*	Reading 01 from address 0000 (from port 0) during cycle 180 (1800ns - 1810ns)
*	Reading 01 from address 1110 (from port 0) during cycle 181 (1810ns - 1820ns)
*	Writing 10  to  address 0000 (from port 0) during cycle 182 (1820ns - 1830ns)
*	Reading 01 from address 1110 (from port 0) during cycle 183 (1830ns - 1840ns)
*	Reading 01 from address 1110 (from port 0) during cycle 184 (1840ns - 1850ns)
*	Writing 10  to  address 1110 (from port 0) during cycle 185 (1850ns - 1860ns)
*	Reading 10 from address 0000 (from port 0) during cycle 187 (1870ns - 1880ns)
*	Reading 10 from address 0000 (from port 0) during cycle 190 (1900ns - 1910ns)
*	Writing 01  to  address 0000 (from port 0) during cycle 191 (1910ns - 1920ns)
*	Reading 01 from address 0000 (from port 0) during cycle 193 (1930ns - 1940ns)
*	Writing 01  to  address 0000 (from port 0) during cycle 194 (1940ns - 1950ns)
*	Reading 01 from address 0000 (from port 0) during cycle 195 (1950ns - 1960ns)
*	Reading 10 from address 1110 (from port 0) during cycle 196 (1960ns - 1970ns)
*	Reading 10 from address 1110 (from port 0) during cycle 197 (1970ns - 1980ns)
*	Reading 01 from address 0000 (from port 0) during cycle 198 (1980ns - 1990ns)
*	Reading 10 from address 1110 (from port 0) during cycle 199 (1990ns - 2000ns)
*	Reading 01 from address 0000 (from port 0) during cycle 200 (2000ns - 2010ns)
*	Reading 10 from address 1110 (from port 0) during cycle 201 (2010ns - 2020ns)
*	Writing 11  to  address 1110 (from port 0) during cycle 203 (2030ns - 2040ns)
*	Reading 11 from address 1110 (from port 0) during cycle 204 (2040ns - 2050ns)
*	Idle during cycle 205 (2050ns - 2060ns)

* Generation of data and address signals
* (time, data): [(0, 0), (10, 1), (20, 1), (30, 0), (40, 0), (50, 1), (60, 1), (70, 1), (80, 1), (90, 1), (100, 1), (110, 1), (120, 1), (130, 1), (140, 1), (150, 1), (160, 1), (170, 1), (180, 1), (190, 1), (200, 1), (210, 1), (220, 1), (230, 1), (240, 0), (250, 0), (260, 0), (270, 0), (280, 0), (290, 0), (300, 0), (310, 1), (320, 1), (330, 1), (340, 1), (350, 1), (360, 1), (370, 1), (380, 0), (390, 1), (400, 1), (410, 1), (420, 1), (430, 1), (440, 1), (450, 1), (460, 1), (470, 1), (480, 1), (490, 1), (500, 1), (510, 1), (520, 1), (530, 1), (540, 1), (550, 0), (560, 0), (570, 0), (580, 1), (590, 0), (600, 0), (610, 0), (620, 0), (630, 0), (640, 0), (650, 0), (660, 0), (670, 0), (680, 0), (690, 1), (700, 1), (710, 1), (720, 1), (730, 1), (740, 1), (750, 1), (760, 1), (770, 1), (780, 1), (790, 0), (800, 1), (810, 1), (820, 1), (830, 1), (840, 1), (850, 1), (860, 1), (870, 1), (880, 1), (890, 1), (900, 0), (910, 0), (920, 0), (930, 0), (940, 0), (950, 0), (960, 0), (970, 0), (980, 1), (990, 1), (1000, 0), (1010, 0), (1020, 0), (1030, 1), (1040, 0), (1050, 0), (1060, 0), (1070, 0), (1080, 0), (1090, 0), (1100, 0), (1110, 0), (1120, 0), (1130, 1), (1140, 0), (1150, 0), (1160, 1), (1170, 0), (1180, 1), (1190, 1), (1200, 1), (1210, 1), (1220, 1), (1230, 1), (1240, 1), (1250, 1), (1260, 1), (1270, 1), (1280, 1), (1290, 1), (1300, 1), (1310, 1), (1320, 1), (1330, 0), (1340, 0), (1350, 0), (1360, 0), (1370, 0), (1380, 0), (1390, 0), (1400, 1), (1410, 0), (1420, 0), (1430, 0), (1440, 1), (1450, 1), (1460, 1), (1470, 1), (1480, 1), (1490, 1), (1500, 1), (1510, 1), (1520, 1), (1530, 1), (1540, 0), (1550, 0), (1560, 0), (1570, 0), (1580, 0), (1590, 0), (1600, 0), (1610, 0), (1620, 0), (1630, 0), (1640, 0), (1650, 0), (1660, 1), (1670, 1), (1680, 1), (1690, 1), (1700, 1), (1710, 1), (1720, 1), (1730, 1), (1740, 1), (1750, 1), (1760, 1), (1770, 1), (1780, 1), (1790, 1), (1800, 1), (1810, 1), (1820, 0), (1830, 0), (1840, 0), (1850, 0), (1860, 0), (1870, 0), (1880, 0), (1890, 0), (1900, 0), (1910, 1), (1920, 1), (1930, 1), (1940, 1), (1950, 1), (1960, 1), (1970, 1), (1980, 1), (1990, 1), (2000, 1), (2010, 1), (2020, 1), (2030, 1), (2040, 1), (2050, 1)]
Vdin0_0  din0_0  0 PWL (0n 0.0v 9.45n 0.0v 9.55n 3.3v 19.45n 3.3v 19.55n 3.3v 29.45n 3.3v 29.55n 0.0v 39.45n 0.0v 39.55n 0.0v 49.45n 0.0v 49.55n 3.3v 59.45n 3.3v 59.55n 3.3v 69.45n 3.3v 69.55n 3.3v 79.45n 3.3v 79.55n 3.3v 89.45n 3.3v 89.55n 3.3v 99.45n 3.3v 99.55n 3.3v 109.45n 3.3v 109.55n 3.3v 119.45n 3.3v 119.55n 3.3v 129.45n 3.3v 129.55n 3.3v 139.45n 3.3v 139.55n 3.3v 149.45n 3.3v 149.55n 3.3v 159.45n 3.3v 159.55n 3.3v 169.45n 3.3v 169.55n 3.3v 179.45n 3.3v 179.55n 3.3v 189.45n 3.3v 189.55n 3.3v 199.45n 3.3v 199.55n 3.3v 209.45n 3.3v 209.55n 3.3v 219.45n 3.3v 219.55n 3.3v 229.45n 3.3v 229.55n 3.3v 239.45n 3.3v 239.55n 0.0v 249.45n 0.0v 249.55n 0.0v 259.45n 0.0v 259.55n 0.0v 269.45n 0.0v 269.55n 0.0v 279.45n 0.0v 279.55n 0.0v 289.45n 0.0v 289.55n 0.0v 299.45n 0.0v 299.55n 0.0v 309.45n 0.0v 309.55n 3.3v 319.45n 3.3v 319.55n 3.3v 329.45n 3.3v 329.55n 3.3v 339.45n 3.3v 339.55n 3.3v 349.45n 3.3v 349.55n 3.3v 359.45n 3.3v 359.55n 3.3v 369.45n 3.3v 369.55n 3.3v 379.45n 3.3v 379.55n 0.0v 389.45n 0.0v 389.55n 3.3v 399.45n 3.3v 399.55n 3.3v 409.45n 3.3v 409.55n 3.3v 419.45n 3.3v 419.55n 3.3v 429.45n 3.3v 429.55n 3.3v 439.45n 3.3v 439.55n 3.3v 449.45n 3.3v 449.55n 3.3v 459.45n 3.3v 459.55n 3.3v 469.45n 3.3v 469.55n 3.3v 479.45n 3.3v 479.55n 3.3v 489.45n 3.3v 489.55n 3.3v 499.45n 3.3v 499.55n 3.3v 509.45n 3.3v 509.55n 3.3v 519.45n 3.3v 519.55n 3.3v 529.45n 3.3v 529.55n 3.3v 539.45n 3.3v 539.55n 3.3v 549.45n 3.3v 549.55n 0.0v 559.45n 0.0v 559.55n 0.0v 569.45n 0.0v 569.55n 0.0v 579.45n 0.0v 579.55n 3.3v 589.45n 3.3v 589.55n 0.0v 599.45n 0.0v 599.55n 0.0v 609.45n 0.0v 609.55n 0.0v 619.45n 0.0v 619.55n 0.0v 629.45n 0.0v 629.55n 0.0v 639.45n 0.0v 639.55n 0.0v 649.45n 0.0v 649.55n 0.0v 659.45n 0.0v 659.55n 0.0v 669.45n 0.0v 669.55n 0.0v 679.45n 0.0v 679.55n 0.0v 689.45n 0.0v 689.55n 3.3v 699.45n 3.3v 699.55n 3.3v 709.45n 3.3v 709.55n 3.3v 719.45n 3.3v 719.55n 3.3v 729.45n 3.3v 729.55n 3.3v 739.45n 3.3v 739.55n 3.3v 749.45n 3.3v 749.55n 3.3v 759.45n 3.3v 759.55n 3.3v 769.45n 3.3v 769.55n 3.3v 779.45n 3.3v 779.55n 3.3v 789.45n 3.3v 789.55n 0.0v 799.45n 0.0v 799.55n 3.3v 809.45n 3.3v 809.55n 3.3v 819.45n 3.3v 819.55n 3.3v 829.45n 3.3v 829.55n 3.3v 839.45n 3.3v 839.55n 3.3v 849.45n 3.3v 849.55n 3.3v 859.45n 3.3v 859.55n 3.3v 869.45n 3.3v 869.55n 3.3v 879.45n 3.3v 879.55n 3.3v 889.45n 3.3v 889.55n 3.3v 899.45n 3.3v 899.55n 0.0v 909.45n 0.0v 909.55n 0.0v 919.45n 0.0v 919.55n 0.0v 929.45n 0.0v 929.55n 0.0v 939.45n 0.0v 939.55n 0.0v 949.45n 0.0v 949.55n 0.0v 959.45n 0.0v 959.55n 0.0v 969.45n 0.0v 969.55n 0.0v 979.45n 0.0v 979.55n 3.3v 989.45n 3.3v 989.55n 3.3v 999.45n 3.3v 999.55n 0.0v 1009.45n 0.0v 1009.55n 0.0v 1019.45n 0.0v 1019.55n 0.0v 1029.45n 0.0v 1029.55n 3.3v 1039.45n 3.3v 1039.55n 0.0v 1049.45n 0.0v 1049.55n 0.0v 1059.45n 0.0v 1059.55n 0.0v 1069.45n 0.0v 1069.55n 0.0v 1079.45n 0.0v 1079.55n 0.0v 1089.45n 0.0v 1089.55n 0.0v 1099.45n 0.0v 1099.55n 0.0v 1109.45n 0.0v 1109.55n 0.0v 1119.45n 0.0v 1119.55n 0.0v 1129.45n 0.0v 1129.55n 3.3v 1139.45n 3.3v 1139.55n 0.0v 1149.45n 0.0v 1149.55n 0.0v 1159.45n 0.0v 1159.55n 3.3v 1169.45n 3.3v 1169.55n 0.0v 1179.45n 0.0v 1179.55n 3.3v 1189.45n 3.3v 1189.55n 3.3v 1199.45n 3.3v 1199.55n 3.3v 1209.45n 3.3v 1209.55n 3.3v 1219.45n 3.3v 1219.55n 3.3v 1229.45n 3.3v 1229.55n 3.3v 1239.45n 3.3v 1239.55n 3.3v 1249.45n 3.3v 1249.55n 3.3v 1259.45n 3.3v 1259.55n 3.3v 1269.45n 3.3v 1269.55n 3.3v 1279.45n 3.3v 1279.55n 3.3v 1289.45n 3.3v 1289.55n 3.3v 1299.45n 3.3v 1299.55n 3.3v 1309.45n 3.3v 1309.55n 3.3v 1319.45n 3.3v 1319.55n 3.3v 1329.45n 3.3v 1329.55n 0.0v 1339.45n 0.0v 1339.55n 0.0v 1349.45n 0.0v 1349.55n 0.0v 1359.45n 0.0v 1359.55n 0.0v 1369.45n 0.0v 1369.55n 0.0v 1379.45n 0.0v 1379.55n 0.0v 1389.45n 0.0v 1389.55n 0.0v 1399.45n 0.0v 1399.55n 3.3v 1409.45n 3.3v 1409.55n 0.0v 1419.45n 0.0v 1419.55n 0.0v 1429.45n 0.0v 1429.55n 0.0v 1439.45n 0.0v 1439.55n 3.3v 1449.45n 3.3v 1449.55n 3.3v 1459.45n 3.3v 1459.55n 3.3v 1469.45n 3.3v 1469.55n 3.3v 1479.45n 3.3v 1479.55n 3.3v 1489.45n 3.3v 1489.55n 3.3v 1499.45n 3.3v 1499.55n 3.3v 1509.45n 3.3v 1509.55n 3.3v 1519.45n 3.3v 1519.55n 3.3v 1529.45n 3.3v 1529.55n 3.3v 1539.45n 3.3v 1539.55n 0.0v 1549.45n 0.0v 1549.55n 0.0v 1559.45n 0.0v 1559.55n 0.0v 1569.45n 0.0v 1569.55n 0.0v 1579.45n 0.0v 1579.55n 0.0v 1589.45n 0.0v 1589.55n 0.0v 1599.45n 0.0v 1599.55n 0.0v 1609.45n 0.0v 1609.55n 0.0v 1619.45n 0.0v 1619.55n 0.0v 1629.45n 0.0v 1629.55n 0.0v 1639.45n 0.0v 1639.55n 0.0v 1649.45n 0.0v 1649.55n 0.0v 1659.45n 0.0v 1659.55n 3.3v 1669.45n 3.3v 1669.55n 3.3v 1679.45n 3.3v 1679.55n 3.3v 1689.45n 3.3v 1689.55n 3.3v 1699.45n 3.3v 1699.55n 3.3v 1709.45n 3.3v 1709.55n 3.3v 1719.45n 3.3v 1719.55n 3.3v 1729.45n 3.3v 1729.55n 3.3v 1739.45n 3.3v 1739.55n 3.3v 1749.45n 3.3v 1749.55n 3.3v 1759.45n 3.3v 1759.55n 3.3v 1769.45n 3.3v 1769.55n 3.3v 1779.45n 3.3v 1779.55n 3.3v 1789.45n 3.3v 1789.55n 3.3v 1799.45n 3.3v 1799.55n 3.3v 1809.45n 3.3v 1809.55n 3.3v 1819.45n 3.3v 1819.55n 0.0v 1829.45n 0.0v 1829.55n 0.0v 1839.45n 0.0v 1839.55n 0.0v 1849.45n 0.0v 1849.55n 0.0v 1859.45n 0.0v 1859.55n 0.0v 1869.45n 0.0v 1869.55n 0.0v 1879.45n 0.0v 1879.55n 0.0v 1889.45n 0.0v 1889.55n 0.0v 1899.45n 0.0v 1899.55n 0.0v 1909.45n 0.0v 1909.55n 3.3v 1919.45n 3.3v 1919.55n 3.3v 1929.45n 3.3v 1929.55n 3.3v 1939.45n 3.3v 1939.55n 3.3v 1949.45n 3.3v 1949.55n 3.3v 1959.45n 3.3v 1959.55n 3.3v 1969.45n 3.3v 1969.55n 3.3v 1979.45n 3.3v 1979.55n 3.3v 1989.45n 3.3v 1989.55n 3.3v 1999.45n 3.3v 1999.55n 3.3v 2009.45n 3.3v 2009.55n 3.3v 2019.45n 3.3v 2019.55n 3.3v 2029.45n 3.3v 2029.55n 3.3v 2039.45n 3.3v 2039.55n 3.3v 2049.45n 3.3v 2049.55n 3.3v )
* (time, data): [(0, 0), (10, 1), (20, 0), (30, 1), (40, 1), (50, 0), (60, 0), (70, 0), (80, 0), (90, 1), (100, 1), (110, 1), (120, 0), (130, 0), (140, 0), (150, 0), (160, 1), (170, 1), (180, 0), (190, 0), (200, 0), (210, 0), (220, 0), (230, 0), (240, 1), (250, 1), (260, 1), (270, 1), (280, 1), (290, 1), (300, 1), (310, 1), (320, 1), (330, 1), (340, 1), (350, 1), (360, 1), (370, 1), (380, 1), (390, 0), (400, 0), (410, 0), (420, 0), (430, 0), (440, 0), (450, 0), (460, 0), (470, 0), (480, 0), (490, 0), (500, 0), (510, 0), (520, 0), (530, 0), (540, 1), (550, 1), (560, 1), (570, 1), (580, 0), (590, 1), (600, 1), (610, 1), (620, 1), (630, 1), (640, 1), (650, 1), (660, 1), (670, 1), (680, 1), (690, 1), (700, 1), (710, 1), (720, 1), (730, 1), (740, 1), (750, 1), (760, 1), (770, 1), (780, 1), (790, 1), (800, 1), (810, 1), (820, 1), (830, 1), (840, 1), (850, 1), (860, 1), (870, 1), (880, 1), (890, 1), (900, 1), (910, 1), (920, 1), (930, 1), (940, 1), (950, 1), (960, 1), (970, 1), (980, 0), (990, 0), (1000, 1), (1010, 1), (1020, 1), (1030, 1), (1040, 1), (1050, 1), (1060, 1), (1070, 1), (1080, 1), (1090, 1), (1100, 1), (1110, 1), (1120, 1), (1130, 1), (1140, 1), (1150, 1), (1160, 0), (1170, 1), (1180, 1), (1190, 1), (1200, 1), (1210, 1), (1220, 1), (1230, 1), (1240, 1), (1250, 1), (1260, 1), (1270, 1), (1280, 1), (1290, 1), (1300, 0), (1310, 0), (1320, 0), (1330, 1), (1340, 1), (1350, 1), (1360, 1), (1370, 1), (1380, 1), (1390, 1), (1400, 1), (1410, 1), (1420, 1), (1430, 1), (1440, 0), (1450, 0), (1460, 1), (1470, 1), (1480, 1), (1490, 1), (1500, 1), (1510, 1), (1520, 1), (1530, 1), (1540, 1), (1550, 1), (1560, 1), (1570, 1), (1580, 1), (1590, 1), (1600, 1), (1610, 1), (1620, 1), (1630, 1), (1640, 1), (1650, 1), (1660, 0), (1670, 0), (1680, 0), (1690, 0), (1700, 0), (1710, 0), (1720, 0), (1730, 0), (1740, 0), (1750, 0), (1760, 0), (1770, 0), (1780, 0), (1790, 0), (1800, 0), (1810, 0), (1820, 1), (1830, 1), (1840, 1), (1850, 1), (1860, 1), (1870, 1), (1880, 1), (1890, 1), (1900, 1), (1910, 0), (1920, 0), (1930, 0), (1940, 0), (1950, 0), (1960, 0), (1970, 0), (1980, 0), (1990, 0), (2000, 0), (2010, 0), (2020, 0), (2030, 1), (2040, 1), (2050, 1)]
Vdin0_1  din0_1  0 PWL (0n 0.0v 9.45n 0.0v 9.55n 3.3v 19.45n 3.3v 19.55n 0.0v 29.45n 0.0v 29.55n 3.3v 39.45n 3.3v 39.55n 3.3v 49.45n 3.3v 49.55n 0.0v 59.45n 0.0v 59.55n 0.0v 69.45n 0.0v 69.55n 0.0v 79.45n 0.0v 79.55n 0.0v 89.45n 0.0v 89.55n 3.3v 99.45n 3.3v 99.55n 3.3v 109.45n 3.3v 109.55n 3.3v 119.45n 3.3v 119.55n 0.0v 129.45n 0.0v 129.55n 0.0v 139.45n 0.0v 139.55n 0.0v 149.45n 0.0v 149.55n 0.0v 159.45n 0.0v 159.55n 3.3v 169.45n 3.3v 169.55n 3.3v 179.45n 3.3v 179.55n 0.0v 189.45n 0.0v 189.55n 0.0v 199.45n 0.0v 199.55n 0.0v 209.45n 0.0v 209.55n 0.0v 219.45n 0.0v 219.55n 0.0v 229.45n 0.0v 229.55n 0.0v 239.45n 0.0v 239.55n 3.3v 249.45n 3.3v 249.55n 3.3v 259.45n 3.3v 259.55n 3.3v 269.45n 3.3v 269.55n 3.3v 279.45n 3.3v 279.55n 3.3v 289.45n 3.3v 289.55n 3.3v 299.45n 3.3v 299.55n 3.3v 309.45n 3.3v 309.55n 3.3v 319.45n 3.3v 319.55n 3.3v 329.45n 3.3v 329.55n 3.3v 339.45n 3.3v 339.55n 3.3v 349.45n 3.3v 349.55n 3.3v 359.45n 3.3v 359.55n 3.3v 369.45n 3.3v 369.55n 3.3v 379.45n 3.3v 379.55n 3.3v 389.45n 3.3v 389.55n 0.0v 399.45n 0.0v 399.55n 0.0v 409.45n 0.0v 409.55n 0.0v 419.45n 0.0v 419.55n 0.0v 429.45n 0.0v 429.55n 0.0v 439.45n 0.0v 439.55n 0.0v 449.45n 0.0v 449.55n 0.0v 459.45n 0.0v 459.55n 0.0v 469.45n 0.0v 469.55n 0.0v 479.45n 0.0v 479.55n 0.0v 489.45n 0.0v 489.55n 0.0v 499.45n 0.0v 499.55n 0.0v 509.45n 0.0v 509.55n 0.0v 519.45n 0.0v 519.55n 0.0v 529.45n 0.0v 529.55n 0.0v 539.45n 0.0v 539.55n 3.3v 549.45n 3.3v 549.55n 3.3v 559.45n 3.3v 559.55n 3.3v 569.45n 3.3v 569.55n 3.3v 579.45n 3.3v 579.55n 0.0v 589.45n 0.0v 589.55n 3.3v 599.45n 3.3v 599.55n 3.3v 609.45n 3.3v 609.55n 3.3v 619.45n 3.3v 619.55n 3.3v 629.45n 3.3v 629.55n 3.3v 639.45n 3.3v 639.55n 3.3v 649.45n 3.3v 649.55n 3.3v 659.45n 3.3v 659.55n 3.3v 669.45n 3.3v 669.55n 3.3v 679.45n 3.3v 679.55n 3.3v 689.45n 3.3v 689.55n 3.3v 699.45n 3.3v 699.55n 3.3v 709.45n 3.3v 709.55n 3.3v 719.45n 3.3v 719.55n 3.3v 729.45n 3.3v 729.55n 3.3v 739.45n 3.3v 739.55n 3.3v 749.45n 3.3v 749.55n 3.3v 759.45n 3.3v 759.55n 3.3v 769.45n 3.3v 769.55n 3.3v 779.45n 3.3v 779.55n 3.3v 789.45n 3.3v 789.55n 3.3v 799.45n 3.3v 799.55n 3.3v 809.45n 3.3v 809.55n 3.3v 819.45n 3.3v 819.55n 3.3v 829.45n 3.3v 829.55n 3.3v 839.45n 3.3v 839.55n 3.3v 849.45n 3.3v 849.55n 3.3v 859.45n 3.3v 859.55n 3.3v 869.45n 3.3v 869.55n 3.3v 879.45n 3.3v 879.55n 3.3v 889.45n 3.3v 889.55n 3.3v 899.45n 3.3v 899.55n 3.3v 909.45n 3.3v 909.55n 3.3v 919.45n 3.3v 919.55n 3.3v 929.45n 3.3v 929.55n 3.3v 939.45n 3.3v 939.55n 3.3v 949.45n 3.3v 949.55n 3.3v 959.45n 3.3v 959.55n 3.3v 969.45n 3.3v 969.55n 3.3v 979.45n 3.3v 979.55n 0.0v 989.45n 0.0v 989.55n 0.0v 999.45n 0.0v 999.55n 3.3v 1009.45n 3.3v 1009.55n 3.3v 1019.45n 3.3v 1019.55n 3.3v 1029.45n 3.3v 1029.55n 3.3v 1039.45n 3.3v 1039.55n 3.3v 1049.45n 3.3v 1049.55n 3.3v 1059.45n 3.3v 1059.55n 3.3v 1069.45n 3.3v 1069.55n 3.3v 1079.45n 3.3v 1079.55n 3.3v 1089.45n 3.3v 1089.55n 3.3v 1099.45n 3.3v 1099.55n 3.3v 1109.45n 3.3v 1109.55n 3.3v 1119.45n 3.3v 1119.55n 3.3v 1129.45n 3.3v 1129.55n 3.3v 1139.45n 3.3v 1139.55n 3.3v 1149.45n 3.3v 1149.55n 3.3v 1159.45n 3.3v 1159.55n 0.0v 1169.45n 0.0v 1169.55n 3.3v 1179.45n 3.3v 1179.55n 3.3v 1189.45n 3.3v 1189.55n 3.3v 1199.45n 3.3v 1199.55n 3.3v 1209.45n 3.3v 1209.55n 3.3v 1219.45n 3.3v 1219.55n 3.3v 1229.45n 3.3v 1229.55n 3.3v 1239.45n 3.3v 1239.55n 3.3v 1249.45n 3.3v 1249.55n 3.3v 1259.45n 3.3v 1259.55n 3.3v 1269.45n 3.3v 1269.55n 3.3v 1279.45n 3.3v 1279.55n 3.3v 1289.45n 3.3v 1289.55n 3.3v 1299.45n 3.3v 1299.55n 0.0v 1309.45n 0.0v 1309.55n 0.0v 1319.45n 0.0v 1319.55n 0.0v 1329.45n 0.0v 1329.55n 3.3v 1339.45n 3.3v 1339.55n 3.3v 1349.45n 3.3v 1349.55n 3.3v 1359.45n 3.3v 1359.55n 3.3v 1369.45n 3.3v 1369.55n 3.3v 1379.45n 3.3v 1379.55n 3.3v 1389.45n 3.3v 1389.55n 3.3v 1399.45n 3.3v 1399.55n 3.3v 1409.45n 3.3v 1409.55n 3.3v 1419.45n 3.3v 1419.55n 3.3v 1429.45n 3.3v 1429.55n 3.3v 1439.45n 3.3v 1439.55n 0.0v 1449.45n 0.0v 1449.55n 0.0v 1459.45n 0.0v 1459.55n 3.3v 1469.45n 3.3v 1469.55n 3.3v 1479.45n 3.3v 1479.55n 3.3v 1489.45n 3.3v 1489.55n 3.3v 1499.45n 3.3v 1499.55n 3.3v 1509.45n 3.3v 1509.55n 3.3v 1519.45n 3.3v 1519.55n 3.3v 1529.45n 3.3v 1529.55n 3.3v 1539.45n 3.3v 1539.55n 3.3v 1549.45n 3.3v 1549.55n 3.3v 1559.45n 3.3v 1559.55n 3.3v 1569.45n 3.3v 1569.55n 3.3v 1579.45n 3.3v 1579.55n 3.3v 1589.45n 3.3v 1589.55n 3.3v 1599.45n 3.3v 1599.55n 3.3v 1609.45n 3.3v 1609.55n 3.3v 1619.45n 3.3v 1619.55n 3.3v 1629.45n 3.3v 1629.55n 3.3v 1639.45n 3.3v 1639.55n 3.3v 1649.45n 3.3v 1649.55n 3.3v 1659.45n 3.3v 1659.55n 0.0v 1669.45n 0.0v 1669.55n 0.0v 1679.45n 0.0v 1679.55n 0.0v 1689.45n 0.0v 1689.55n 0.0v 1699.45n 0.0v 1699.55n 0.0v 1709.45n 0.0v 1709.55n 0.0v 1719.45n 0.0v 1719.55n 0.0v 1729.45n 0.0v 1729.55n 0.0v 1739.45n 0.0v 1739.55n 0.0v 1749.45n 0.0v 1749.55n 0.0v 1759.45n 0.0v 1759.55n 0.0v 1769.45n 0.0v 1769.55n 0.0v 1779.45n 0.0v 1779.55n 0.0v 1789.45n 0.0v 1789.55n 0.0v 1799.45n 0.0v 1799.55n 0.0v 1809.45n 0.0v 1809.55n 0.0v 1819.45n 0.0v 1819.55n 3.3v 1829.45n 3.3v 1829.55n 3.3v 1839.45n 3.3v 1839.55n 3.3v 1849.45n 3.3v 1849.55n 3.3v 1859.45n 3.3v 1859.55n 3.3v 1869.45n 3.3v 1869.55n 3.3v 1879.45n 3.3v 1879.55n 3.3v 1889.45n 3.3v 1889.55n 3.3v 1899.45n 3.3v 1899.55n 3.3v 1909.45n 3.3v 1909.55n 0.0v 1919.45n 0.0v 1919.55n 0.0v 1929.45n 0.0v 1929.55n 0.0v 1939.45n 0.0v 1939.55n 0.0v 1949.45n 0.0v 1949.55n 0.0v 1959.45n 0.0v 1959.55n 0.0v 1969.45n 0.0v 1969.55n 0.0v 1979.45n 0.0v 1979.55n 0.0v 1989.45n 0.0v 1989.55n 0.0v 1999.45n 0.0v 1999.55n 0.0v 2009.45n 0.0v 2009.55n 0.0v 2019.45n 0.0v 2019.55n 0.0v 2029.45n 0.0v 2029.55n 3.3v 2039.45n 3.3v 2039.55n 3.3v 2049.45n 3.3v 2049.55n 3.3v )
* (time, data): [(0, 0), (10, 0), (20, 0), (30, 0), (40, 0), (50, 0), (60, 0), (70, 0), (80, 0), (90, 0), (100, 0), (110, 0), (120, 0), (130, 0), (140, 0), (150, 0), (160, 0), (170, 0), (180, 0), (190, 0), (200, 0), (210, 0), (220, 0), (230, 0), (240, 0), (250, 0), (260, 0), (270, 0), (280, 0), (290, 0), (300, 0), (310, 0), (320, 0), (330, 0), (340, 0), (350, 0), (360, 0), (370, 0), (380, 0), (390, 0), (400, 0), (410, 0), (420, 0), (430, 0), (440, 0), (450, 0), (460, 0), (470, 0), (480, 0), (490, 0), (500, 0), (510, 0), (520, 0), (530, 0), (540, 0), (550, 0), (560, 0), (570, 0), (580, 0), (590, 0), (600, 0), (610, 0), (620, 0), (630, 0), (640, 0), (650, 0), (660, 0), (670, 0), (680, 0), (690, 0), (700, 0), (710, 0), (720, 0), (730, 0), (740, 0), (750, 0), (760, 0), (770, 0), (780, 0), (790, 0), (800, 0), (810, 0), (820, 0), (830, 0), (840, 0), (850, 0), (860, 0), (870, 0), (880, 0), (890, 0), (900, 0), (910, 0), (920, 0), (930, 0), (940, 0), (950, 0), (960, 0), (970, 0), (980, 0), (990, 0), (1000, 0), (1010, 0), (1020, 0), (1030, 0), (1040, 0), (1050, 0), (1060, 0), (1070, 0), (1080, 0), (1090, 0), (1100, 0), (1110, 0), (1120, 0), (1130, 0), (1140, 0), (1150, 0), (1160, 0), (1170, 0), (1180, 0), (1190, 0), (1200, 0), (1210, 0), (1220, 0), (1230, 0), (1240, 0), (1250, 0), (1260, 0), (1270, 0), (1280, 0), (1290, 0), (1300, 0), (1310, 0), (1320, 0), (1330, 0), (1340, 0), (1350, 0), (1360, 0), (1370, 0), (1380, 0), (1390, 0), (1400, 0), (1410, 0), (1420, 0), (1430, 0), (1440, 0), (1450, 0), (1460, 0), (1470, 0), (1480, 0), (1490, 0), (1500, 0), (1510, 0), (1520, 0), (1530, 0), (1540, 0), (1550, 0), (1560, 0), (1570, 0), (1580, 0), (1590, 0), (1600, 0), (1610, 0), (1620, 0), (1630, 0), (1640, 0), (1650, 0), (1660, 0), (1670, 0), (1680, 0), (1690, 0), (1700, 0), (1710, 0), (1720, 0), (1730, 0), (1740, 0), (1750, 0), (1760, 0), (1770, 0), (1780, 0), (1790, 0), (1800, 0), (1810, 0), (1820, 0), (1830, 0), (1840, 0), (1850, 0), (1860, 0), (1870, 0), (1880, 0), (1890, 0), (1900, 0), (1910, 0), (1920, 0), (1930, 0), (1940, 0), (1950, 0), (1960, 0), (1970, 0), (1980, 0), (1990, 0), (2000, 0), (2010, 0), (2020, 0), (2030, 0), (2040, 0), (2050, 0)]
Va0_0  a0_0  0 PWL (0n 0.0v 9.45n 0.0v 9.55n 0.0v 19.45n 0.0v 19.55n 0.0v 29.45n 0.0v 29.55n 0.0v 39.45n 0.0v 39.55n 0.0v 49.45n 0.0v 49.55n 0.0v 59.45n 0.0v 59.55n 0.0v 69.45n 0.0v 69.55n 0.0v 79.45n 0.0v 79.55n 0.0v 89.45n 0.0v 89.55n 0.0v 99.45n 0.0v 99.55n 0.0v 109.45n 0.0v 109.55n 0.0v 119.45n 0.0v 119.55n 0.0v 129.45n 0.0v 129.55n 0.0v 139.45n 0.0v 139.55n 0.0v 149.45n 0.0v 149.55n 0.0v 159.45n 0.0v 159.55n 0.0v 169.45n 0.0v 169.55n 0.0v 179.45n 0.0v 179.55n 0.0v 189.45n 0.0v 189.55n 0.0v 199.45n 0.0v 199.55n 0.0v 209.45n 0.0v 209.55n 0.0v 219.45n 0.0v 219.55n 0.0v 229.45n 0.0v 229.55n 0.0v 239.45n 0.0v 239.55n 0.0v 249.45n 0.0v 249.55n 0.0v 259.45n 0.0v 259.55n 0.0v 269.45n 0.0v 269.55n 0.0v 279.45n 0.0v 279.55n 0.0v 289.45n 0.0v 289.55n 0.0v 299.45n 0.0v 299.55n 0.0v 309.45n 0.0v 309.55n 0.0v 319.45n 0.0v 319.55n 0.0v 329.45n 0.0v 329.55n 0.0v 339.45n 0.0v 339.55n 0.0v 349.45n 0.0v 349.55n 0.0v 359.45n 0.0v 359.55n 0.0v 369.45n 0.0v 369.55n 0.0v 379.45n 0.0v 379.55n 0.0v 389.45n 0.0v 389.55n 0.0v 399.45n 0.0v 399.55n 0.0v 409.45n 0.0v 409.55n 0.0v 419.45n 0.0v 419.55n 0.0v 429.45n 0.0v 429.55n 0.0v 439.45n 0.0v 439.55n 0.0v 449.45n 0.0v 449.55n 0.0v 459.45n 0.0v 459.55n 0.0v 469.45n 0.0v 469.55n 0.0v 479.45n 0.0v 479.55n 0.0v 489.45n 0.0v 489.55n 0.0v 499.45n 0.0v 499.55n 0.0v 509.45n 0.0v 509.55n 0.0v 519.45n 0.0v 519.55n 0.0v 529.45n 0.0v 529.55n 0.0v 539.45n 0.0v 539.55n 0.0v 549.45n 0.0v 549.55n 0.0v 559.45n 0.0v 559.55n 0.0v 569.45n 0.0v 569.55n 0.0v 579.45n 0.0v 579.55n 0.0v 589.45n 0.0v 589.55n 0.0v 599.45n 0.0v 599.55n 0.0v 609.45n 0.0v 609.55n 0.0v 619.45n 0.0v 619.55n 0.0v 629.45n 0.0v 629.55n 0.0v 639.45n 0.0v 639.55n 0.0v 649.45n 0.0v 649.55n 0.0v 659.45n 0.0v 659.55n 0.0v 669.45n 0.0v 669.55n 0.0v 679.45n 0.0v 679.55n 0.0v 689.45n 0.0v 689.55n 0.0v 699.45n 0.0v 699.55n 0.0v 709.45n 0.0v 709.55n 0.0v 719.45n 0.0v 719.55n 0.0v 729.45n 0.0v 729.55n 0.0v 739.45n 0.0v 739.55n 0.0v 749.45n 0.0v 749.55n 0.0v 759.45n 0.0v 759.55n 0.0v 769.45n 0.0v 769.55n 0.0v 779.45n 0.0v 779.55n 0.0v 789.45n 0.0v 789.55n 0.0v 799.45n 0.0v 799.55n 0.0v 809.45n 0.0v 809.55n 0.0v 819.45n 0.0v 819.55n 0.0v 829.45n 0.0v 829.55n 0.0v 839.45n 0.0v 839.55n 0.0v 849.45n 0.0v 849.55n 0.0v 859.45n 0.0v 859.55n 0.0v 869.45n 0.0v 869.55n 0.0v 879.45n 0.0v 879.55n 0.0v 889.45n 0.0v 889.55n 0.0v 899.45n 0.0v 899.55n 0.0v 909.45n 0.0v 909.55n 0.0v 919.45n 0.0v 919.55n 0.0v 929.45n 0.0v 929.55n 0.0v 939.45n 0.0v 939.55n 0.0v 949.45n 0.0v 949.55n 0.0v 959.45n 0.0v 959.55n 0.0v 969.45n 0.0v 969.55n 0.0v 979.45n 0.0v 979.55n 0.0v 989.45n 0.0v 989.55n 0.0v 999.45n 0.0v 999.55n 0.0v 1009.45n 0.0v 1009.55n 0.0v 1019.45n 0.0v 1019.55n 0.0v 1029.45n 0.0v 1029.55n 0.0v 1039.45n 0.0v 1039.55n 0.0v 1049.45n 0.0v 1049.55n 0.0v 1059.45n 0.0v 1059.55n 0.0v 1069.45n 0.0v 1069.55n 0.0v 1079.45n 0.0v 1079.55n 0.0v 1089.45n 0.0v 1089.55n 0.0v 1099.45n 0.0v 1099.55n 0.0v 1109.45n 0.0v 1109.55n 0.0v 1119.45n 0.0v 1119.55n 0.0v 1129.45n 0.0v 1129.55n 0.0v 1139.45n 0.0v 1139.55n 0.0v 1149.45n 0.0v 1149.55n 0.0v 1159.45n 0.0v 1159.55n 0.0v 1169.45n 0.0v 1169.55n 0.0v 1179.45n 0.0v 1179.55n 0.0v 1189.45n 0.0v 1189.55n 0.0v 1199.45n 0.0v 1199.55n 0.0v 1209.45n 0.0v 1209.55n 0.0v 1219.45n 0.0v 1219.55n 0.0v 1229.45n 0.0v 1229.55n 0.0v 1239.45n 0.0v 1239.55n 0.0v 1249.45n 0.0v 1249.55n 0.0v 1259.45n 0.0v 1259.55n 0.0v 1269.45n 0.0v 1269.55n 0.0v 1279.45n 0.0v 1279.55n 0.0v 1289.45n 0.0v 1289.55n 0.0v 1299.45n 0.0v 1299.55n 0.0v 1309.45n 0.0v 1309.55n 0.0v 1319.45n 0.0v 1319.55n 0.0v 1329.45n 0.0v 1329.55n 0.0v 1339.45n 0.0v 1339.55n 0.0v 1349.45n 0.0v 1349.55n 0.0v 1359.45n 0.0v 1359.55n 0.0v 1369.45n 0.0v 1369.55n 0.0v 1379.45n 0.0v 1379.55n 0.0v 1389.45n 0.0v 1389.55n 0.0v 1399.45n 0.0v 1399.55n 0.0v 1409.45n 0.0v 1409.55n 0.0v 1419.45n 0.0v 1419.55n 0.0v 1429.45n 0.0v 1429.55n 0.0v 1439.45n 0.0v 1439.55n 0.0v 1449.45n 0.0v 1449.55n 0.0v 1459.45n 0.0v 1459.55n 0.0v 1469.45n 0.0v 1469.55n 0.0v 1479.45n 0.0v 1479.55n 0.0v 1489.45n 0.0v 1489.55n 0.0v 1499.45n 0.0v 1499.55n 0.0v 1509.45n 0.0v 1509.55n 0.0v 1519.45n 0.0v 1519.55n 0.0v 1529.45n 0.0v 1529.55n 0.0v 1539.45n 0.0v 1539.55n 0.0v 1549.45n 0.0v 1549.55n 0.0v 1559.45n 0.0v 1559.55n 0.0v 1569.45n 0.0v 1569.55n 0.0v 1579.45n 0.0v 1579.55n 0.0v 1589.45n 0.0v 1589.55n 0.0v 1599.45n 0.0v 1599.55n 0.0v 1609.45n 0.0v 1609.55n 0.0v 1619.45n 0.0v 1619.55n 0.0v 1629.45n 0.0v 1629.55n 0.0v 1639.45n 0.0v 1639.55n 0.0v 1649.45n 0.0v 1649.55n 0.0v 1659.45n 0.0v 1659.55n 0.0v 1669.45n 0.0v 1669.55n 0.0v 1679.45n 0.0v 1679.55n 0.0v 1689.45n 0.0v 1689.55n 0.0v 1699.45n 0.0v 1699.55n 0.0v 1709.45n 0.0v 1709.55n 0.0v 1719.45n 0.0v 1719.55n 0.0v 1729.45n 0.0v 1729.55n 0.0v 1739.45n 0.0v 1739.55n 0.0v 1749.45n 0.0v 1749.55n 0.0v 1759.45n 0.0v 1759.55n 0.0v 1769.45n 0.0v 1769.55n 0.0v 1779.45n 0.0v 1779.55n 0.0v 1789.45n 0.0v 1789.55n 0.0v 1799.45n 0.0v 1799.55n 0.0v 1809.45n 0.0v 1809.55n 0.0v 1819.45n 0.0v 1819.55n 0.0v 1829.45n 0.0v 1829.55n 0.0v 1839.45n 0.0v 1839.55n 0.0v 1849.45n 0.0v 1849.55n 0.0v 1859.45n 0.0v 1859.55n 0.0v 1869.45n 0.0v 1869.55n 0.0v 1879.45n 0.0v 1879.55n 0.0v 1889.45n 0.0v 1889.55n 0.0v 1899.45n 0.0v 1899.55n 0.0v 1909.45n 0.0v 1909.55n 0.0v 1919.45n 0.0v 1919.55n 0.0v 1929.45n 0.0v 1929.55n 0.0v 1939.45n 0.0v 1939.55n 0.0v 1949.45n 0.0v 1949.55n 0.0v 1959.45n 0.0v 1959.55n 0.0v 1969.45n 0.0v 1969.55n 0.0v 1979.45n 0.0v 1979.55n 0.0v 1989.45n 0.0v 1989.55n 0.0v 1999.45n 0.0v 1999.55n 0.0v 2009.45n 0.0v 2009.55n 0.0v 2019.45n 0.0v 2019.55n 0.0v 2029.45n 0.0v 2029.55n 0.0v 2039.45n 0.0v 2039.55n 0.0v 2049.45n 0.0v 2049.55n 0.0v )
* (time, data): [(0, 0), (10, 1), (20, 1), (30, 1), (40, 1), (50, 1), (60, 1), (70, 1), (80, 1), (90, 1), (100, 1), (110, 1), (120, 1), (130, 1), (140, 1), (150, 1), (160, 1), (170, 1), (180, 0), (190, 0), (200, 1), (210, 0), (220, 1), (230, 1), (240, 0), (250, 1), (260, 1), (270, 1), (280, 1), (290, 1), (300, 1), (310, 1), (320, 0), (330, 1), (340, 1), (350, 1), (360, 0), (370, 0), (380, 0), (390, 1), (400, 0), (410, 0), (420, 1), (430, 1), (440, 1), (450, 0), (460, 1), (470, 0), (480, 0), (490, 1), (500, 0), (510, 0), (520, 0), (530, 0), (540, 0), (550, 0), (560, 0), (570, 0), (580, 0), (590, 1), (600, 0), (610, 1), (620, 1), (630, 1), (640, 1), (650, 1), (660, 1), (670, 1), (680, 1), (690, 1), (700, 1), (710, 0), (720, 0), (730, 0), (740, 1), (750, 1), (760, 0), (770, 0), (780, 0), (790, 0), (800, 0), (810, 1), (820, 1), (830, 1), (840, 1), (850, 0), (860, 1), (870, 1), (880, 1), (890, 1), (900, 0), (910, 0), (920, 1), (930, 1), (940, 1), (950, 1), (960, 0), (970, 1), (980, 1), (990, 1), (1000, 0), (1010, 1), (1020, 1), (1030, 1), (1040, 1), (1050, 1), (1060, 0), (1070, 0), (1080, 1), (1090, 1), (1100, 0), (1110, 0), (1120, 0), (1130, 0), (1140, 1), (1150, 1), (1160, 1), (1170, 0), (1180, 0), (1190, 1), (1200, 1), (1210, 1), (1220, 0), (1230, 1), (1240, 1), (1250, 1), (1260, 0), (1270, 1), (1280, 0), (1290, 0), (1300, 1), (1310, 0), (1320, 0), (1330, 1), (1340, 1), (1350, 1), (1360, 0), (1370, 0), (1380, 0), (1390, 1), (1400, 1), (1410, 0), (1420, 0), (1430, 0), (1440, 1), (1450, 1), (1460, 0), (1470, 1), (1480, 1), (1490, 1), (1500, 1), (1510, 0), (1520, 1), (1530, 1), (1540, 0), (1550, 0), (1560, 1), (1570, 1), (1580, 0), (1590, 0), (1600, 1), (1610, 1), (1620, 1), (1630, 1), (1640, 1), (1650, 0), (1660, 0), (1670, 1), (1680, 1), (1690, 1), (1700, 1), (1710, 1), (1720, 0), (1730, 1), (1740, 0), (1750, 1), (1760, 1), (1770, 1), (1780, 1), (1790, 1), (1800, 0), (1810, 1), (1820, 0), (1830, 1), (1840, 1), (1850, 1), (1860, 1), (1870, 0), (1880, 0), (1890, 0), (1900, 0), (1910, 0), (1920, 0), (1930, 0), (1940, 0), (1950, 0), (1960, 1), (1970, 1), (1980, 0), (1990, 1), (2000, 0), (2010, 1), (2020, 1), (2030, 1), (2040, 1), (2050, 1)]
Va0_1  a0_1  0 PWL (0n 0.0v 9.45n 0.0v 9.55n 3.3v 19.45n 3.3v 19.55n 3.3v 29.45n 3.3v 29.55n 3.3v 39.45n 3.3v 39.55n 3.3v 49.45n 3.3v 49.55n 3.3v 59.45n 3.3v 59.55n 3.3v 69.45n 3.3v 69.55n 3.3v 79.45n 3.3v 79.55n 3.3v 89.45n 3.3v 89.55n 3.3v 99.45n 3.3v 99.55n 3.3v 109.45n 3.3v 109.55n 3.3v 119.45n 3.3v 119.55n 3.3v 129.45n 3.3v 129.55n 3.3v 139.45n 3.3v 139.55n 3.3v 149.45n 3.3v 149.55n 3.3v 159.45n 3.3v 159.55n 3.3v 169.45n 3.3v 169.55n 3.3v 179.45n 3.3v 179.55n 0.0v 189.45n 0.0v 189.55n 0.0v 199.45n 0.0v 199.55n 3.3v 209.45n 3.3v 209.55n 0.0v 219.45n 0.0v 219.55n 3.3v 229.45n 3.3v 229.55n 3.3v 239.45n 3.3v 239.55n 0.0v 249.45n 0.0v 249.55n 3.3v 259.45n 3.3v 259.55n 3.3v 269.45n 3.3v 269.55n 3.3v 279.45n 3.3v 279.55n 3.3v 289.45n 3.3v 289.55n 3.3v 299.45n 3.3v 299.55n 3.3v 309.45n 3.3v 309.55n 3.3v 319.45n 3.3v 319.55n 0.0v 329.45n 0.0v 329.55n 3.3v 339.45n 3.3v 339.55n 3.3v 349.45n 3.3v 349.55n 3.3v 359.45n 3.3v 359.55n 0.0v 369.45n 0.0v 369.55n 0.0v 379.45n 0.0v 379.55n 0.0v 389.45n 0.0v 389.55n 3.3v 399.45n 3.3v 399.55n 0.0v 409.45n 0.0v 409.55n 0.0v 419.45n 0.0v 419.55n 3.3v 429.45n 3.3v 429.55n 3.3v 439.45n 3.3v 439.55n 3.3v 449.45n 3.3v 449.55n 0.0v 459.45n 0.0v 459.55n 3.3v 469.45n 3.3v 469.55n 0.0v 479.45n 0.0v 479.55n 0.0v 489.45n 0.0v 489.55n 3.3v 499.45n 3.3v 499.55n 0.0v 509.45n 0.0v 509.55n 0.0v 519.45n 0.0v 519.55n 0.0v 529.45n 0.0v 529.55n 0.0v 539.45n 0.0v 539.55n 0.0v 549.45n 0.0v 549.55n 0.0v 559.45n 0.0v 559.55n 0.0v 569.45n 0.0v 569.55n 0.0v 579.45n 0.0v 579.55n 0.0v 589.45n 0.0v 589.55n 3.3v 599.45n 3.3v 599.55n 0.0v 609.45n 0.0v 609.55n 3.3v 619.45n 3.3v 619.55n 3.3v 629.45n 3.3v 629.55n 3.3v 639.45n 3.3v 639.55n 3.3v 649.45n 3.3v 649.55n 3.3v 659.45n 3.3v 659.55n 3.3v 669.45n 3.3v 669.55n 3.3v 679.45n 3.3v 679.55n 3.3v 689.45n 3.3v 689.55n 3.3v 699.45n 3.3v 699.55n 3.3v 709.45n 3.3v 709.55n 0.0v 719.45n 0.0v 719.55n 0.0v 729.45n 0.0v 729.55n 0.0v 739.45n 0.0v 739.55n 3.3v 749.45n 3.3v 749.55n 3.3v 759.45n 3.3v 759.55n 0.0v 769.45n 0.0v 769.55n 0.0v 779.45n 0.0v 779.55n 0.0v 789.45n 0.0v 789.55n 0.0v 799.45n 0.0v 799.55n 0.0v 809.45n 0.0v 809.55n 3.3v 819.45n 3.3v 819.55n 3.3v 829.45n 3.3v 829.55n 3.3v 839.45n 3.3v 839.55n 3.3v 849.45n 3.3v 849.55n 0.0v 859.45n 0.0v 859.55n 3.3v 869.45n 3.3v 869.55n 3.3v 879.45n 3.3v 879.55n 3.3v 889.45n 3.3v 889.55n 3.3v 899.45n 3.3v 899.55n 0.0v 909.45n 0.0v 909.55n 0.0v 919.45n 0.0v 919.55n 3.3v 929.45n 3.3v 929.55n 3.3v 939.45n 3.3v 939.55n 3.3v 949.45n 3.3v 949.55n 3.3v 959.45n 3.3v 959.55n 0.0v 969.45n 0.0v 969.55n 3.3v 979.45n 3.3v 979.55n 3.3v 989.45n 3.3v 989.55n 3.3v 999.45n 3.3v 999.55n 0.0v 1009.45n 0.0v 1009.55n 3.3v 1019.45n 3.3v 1019.55n 3.3v 1029.45n 3.3v 1029.55n 3.3v 1039.45n 3.3v 1039.55n 3.3v 1049.45n 3.3v 1049.55n 3.3v 1059.45n 3.3v 1059.55n 0.0v 1069.45n 0.0v 1069.55n 0.0v 1079.45n 0.0v 1079.55n 3.3v 1089.45n 3.3v 1089.55n 3.3v 1099.45n 3.3v 1099.55n 0.0v 1109.45n 0.0v 1109.55n 0.0v 1119.45n 0.0v 1119.55n 0.0v 1129.45n 0.0v 1129.55n 0.0v 1139.45n 0.0v 1139.55n 3.3v 1149.45n 3.3v 1149.55n 3.3v 1159.45n 3.3v 1159.55n 3.3v 1169.45n 3.3v 1169.55n 0.0v 1179.45n 0.0v 1179.55n 0.0v 1189.45n 0.0v 1189.55n 3.3v 1199.45n 3.3v 1199.55n 3.3v 1209.45n 3.3v 1209.55n 3.3v 1219.45n 3.3v 1219.55n 0.0v 1229.45n 0.0v 1229.55n 3.3v 1239.45n 3.3v 1239.55n 3.3v 1249.45n 3.3v 1249.55n 3.3v 1259.45n 3.3v 1259.55n 0.0v 1269.45n 0.0v 1269.55n 3.3v 1279.45n 3.3v 1279.55n 0.0v 1289.45n 0.0v 1289.55n 0.0v 1299.45n 0.0v 1299.55n 3.3v 1309.45n 3.3v 1309.55n 0.0v 1319.45n 0.0v 1319.55n 0.0v 1329.45n 0.0v 1329.55n 3.3v 1339.45n 3.3v 1339.55n 3.3v 1349.45n 3.3v 1349.55n 3.3v 1359.45n 3.3v 1359.55n 0.0v 1369.45n 0.0v 1369.55n 0.0v 1379.45n 0.0v 1379.55n 0.0v 1389.45n 0.0v 1389.55n 3.3v 1399.45n 3.3v 1399.55n 3.3v 1409.45n 3.3v 1409.55n 0.0v 1419.45n 0.0v 1419.55n 0.0v 1429.45n 0.0v 1429.55n 0.0v 1439.45n 0.0v 1439.55n 3.3v 1449.45n 3.3v 1449.55n 3.3v 1459.45n 3.3v 1459.55n 0.0v 1469.45n 0.0v 1469.55n 3.3v 1479.45n 3.3v 1479.55n 3.3v 1489.45n 3.3v 1489.55n 3.3v 1499.45n 3.3v 1499.55n 3.3v 1509.45n 3.3v 1509.55n 0.0v 1519.45n 0.0v 1519.55n 3.3v 1529.45n 3.3v 1529.55n 3.3v 1539.45n 3.3v 1539.55n 0.0v 1549.45n 0.0v 1549.55n 0.0v 1559.45n 0.0v 1559.55n 3.3v 1569.45n 3.3v 1569.55n 3.3v 1579.45n 3.3v 1579.55n 0.0v 1589.45n 0.0v 1589.55n 0.0v 1599.45n 0.0v 1599.55n 3.3v 1609.45n 3.3v 1609.55n 3.3v 1619.45n 3.3v 1619.55n 3.3v 1629.45n 3.3v 1629.55n 3.3v 1639.45n 3.3v 1639.55n 3.3v 1649.45n 3.3v 1649.55n 0.0v 1659.45n 0.0v 1659.55n 0.0v 1669.45n 0.0v 1669.55n 3.3v 1679.45n 3.3v 1679.55n 3.3v 1689.45n 3.3v 1689.55n 3.3v 1699.45n 3.3v 1699.55n 3.3v 1709.45n 3.3v 1709.55n 3.3v 1719.45n 3.3v 1719.55n 0.0v 1729.45n 0.0v 1729.55n 3.3v 1739.45n 3.3v 1739.55n 0.0v 1749.45n 0.0v 1749.55n 3.3v 1759.45n 3.3v 1759.55n 3.3v 1769.45n 3.3v 1769.55n 3.3v 1779.45n 3.3v 1779.55n 3.3v 1789.45n 3.3v 1789.55n 3.3v 1799.45n 3.3v 1799.55n 0.0v 1809.45n 0.0v 1809.55n 3.3v 1819.45n 3.3v 1819.55n 0.0v 1829.45n 0.0v 1829.55n 3.3v 1839.45n 3.3v 1839.55n 3.3v 1849.45n 3.3v 1849.55n 3.3v 1859.45n 3.3v 1859.55n 3.3v 1869.45n 3.3v 1869.55n 0.0v 1879.45n 0.0v 1879.55n 0.0v 1889.45n 0.0v 1889.55n 0.0v 1899.45n 0.0v 1899.55n 0.0v 1909.45n 0.0v 1909.55n 0.0v 1919.45n 0.0v 1919.55n 0.0v 1929.45n 0.0v 1929.55n 0.0v 1939.45n 0.0v 1939.55n 0.0v 1949.45n 0.0v 1949.55n 0.0v 1959.45n 0.0v 1959.55n 3.3v 1969.45n 3.3v 1969.55n 3.3v 1979.45n 3.3v 1979.55n 0.0v 1989.45n 0.0v 1989.55n 3.3v 1999.45n 3.3v 1999.55n 0.0v 2009.45n 0.0v 2009.55n 3.3v 2019.45n 3.3v 2019.55n 3.3v 2029.45n 3.3v 2029.55n 3.3v 2039.45n 3.3v 2039.55n 3.3v 2049.45n 3.3v 2049.55n 3.3v )
* (time, data): [(0, 0), (10, 1), (20, 1), (30, 1), (40, 1), (50, 1), (60, 1), (70, 1), (80, 1), (90, 1), (100, 1), (110, 1), (120, 1), (130, 1), (140, 1), (150, 1), (160, 1), (170, 1), (180, 0), (190, 0), (200, 1), (210, 0), (220, 1), (230, 1), (240, 0), (250, 1), (260, 1), (270, 1), (280, 1), (290, 1), (300, 1), (310, 1), (320, 0), (330, 1), (340, 1), (350, 1), (360, 0), (370, 0), (380, 0), (390, 1), (400, 0), (410, 0), (420, 1), (430, 1), (440, 1), (450, 0), (460, 1), (470, 0), (480, 0), (490, 1), (500, 0), (510, 0), (520, 0), (530, 0), (540, 0), (550, 0), (560, 0), (570, 0), (580, 0), (590, 1), (600, 0), (610, 1), (620, 1), (630, 1), (640, 1), (650, 1), (660, 1), (670, 1), (680, 1), (690, 1), (700, 1), (710, 0), (720, 0), (730, 0), (740, 1), (750, 1), (760, 0), (770, 0), (780, 0), (790, 0), (800, 0), (810, 1), (820, 1), (830, 1), (840, 1), (850, 0), (860, 1), (870, 1), (880, 1), (890, 1), (900, 0), (910, 0), (920, 1), (930, 1), (940, 1), (950, 1), (960, 0), (970, 1), (980, 1), (990, 1), (1000, 0), (1010, 1), (1020, 1), (1030, 1), (1040, 1), (1050, 1), (1060, 0), (1070, 0), (1080, 1), (1090, 1), (1100, 0), (1110, 0), (1120, 0), (1130, 0), (1140, 1), (1150, 1), (1160, 1), (1170, 0), (1180, 0), (1190, 1), (1200, 1), (1210, 1), (1220, 0), (1230, 1), (1240, 1), (1250, 1), (1260, 0), (1270, 1), (1280, 0), (1290, 0), (1300, 1), (1310, 0), (1320, 0), (1330, 1), (1340, 1), (1350, 1), (1360, 0), (1370, 0), (1380, 0), (1390, 1), (1400, 1), (1410, 0), (1420, 0), (1430, 0), (1440, 1), (1450, 1), (1460, 0), (1470, 1), (1480, 1), (1490, 1), (1500, 1), (1510, 0), (1520, 1), (1530, 1), (1540, 0), (1550, 0), (1560, 1), (1570, 1), (1580, 0), (1590, 0), (1600, 1), (1610, 1), (1620, 1), (1630, 1), (1640, 1), (1650, 0), (1660, 0), (1670, 1), (1680, 1), (1690, 1), (1700, 1), (1710, 1), (1720, 0), (1730, 1), (1740, 0), (1750, 1), (1760, 1), (1770, 1), (1780, 1), (1790, 1), (1800, 0), (1810, 1), (1820, 0), (1830, 1), (1840, 1), (1850, 1), (1860, 1), (1870, 0), (1880, 0), (1890, 0), (1900, 0), (1910, 0), (1920, 0), (1930, 0), (1940, 0), (1950, 0), (1960, 1), (1970, 1), (1980, 0), (1990, 1), (2000, 0), (2010, 1), (2020, 1), (2030, 1), (2040, 1), (2050, 1)]
Va0_2  a0_2  0 PWL (0n 0.0v 9.45n 0.0v 9.55n 3.3v 19.45n 3.3v 19.55n 3.3v 29.45n 3.3v 29.55n 3.3v 39.45n 3.3v 39.55n 3.3v 49.45n 3.3v 49.55n 3.3v 59.45n 3.3v 59.55n 3.3v 69.45n 3.3v 69.55n 3.3v 79.45n 3.3v 79.55n 3.3v 89.45n 3.3v 89.55n 3.3v 99.45n 3.3v 99.55n 3.3v 109.45n 3.3v 109.55n 3.3v 119.45n 3.3v 119.55n 3.3v 129.45n 3.3v 129.55n 3.3v 139.45n 3.3v 139.55n 3.3v 149.45n 3.3v 149.55n 3.3v 159.45n 3.3v 159.55n 3.3v 169.45n 3.3v 169.55n 3.3v 179.45n 3.3v 179.55n 0.0v 189.45n 0.0v 189.55n 0.0v 199.45n 0.0v 199.55n 3.3v 209.45n 3.3v 209.55n 0.0v 219.45n 0.0v 219.55n 3.3v 229.45n 3.3v 229.55n 3.3v 239.45n 3.3v 239.55n 0.0v 249.45n 0.0v 249.55n 3.3v 259.45n 3.3v 259.55n 3.3v 269.45n 3.3v 269.55n 3.3v 279.45n 3.3v 279.55n 3.3v 289.45n 3.3v 289.55n 3.3v 299.45n 3.3v 299.55n 3.3v 309.45n 3.3v 309.55n 3.3v 319.45n 3.3v 319.55n 0.0v 329.45n 0.0v 329.55n 3.3v 339.45n 3.3v 339.55n 3.3v 349.45n 3.3v 349.55n 3.3v 359.45n 3.3v 359.55n 0.0v 369.45n 0.0v 369.55n 0.0v 379.45n 0.0v 379.55n 0.0v 389.45n 0.0v 389.55n 3.3v 399.45n 3.3v 399.55n 0.0v 409.45n 0.0v 409.55n 0.0v 419.45n 0.0v 419.55n 3.3v 429.45n 3.3v 429.55n 3.3v 439.45n 3.3v 439.55n 3.3v 449.45n 3.3v 449.55n 0.0v 459.45n 0.0v 459.55n 3.3v 469.45n 3.3v 469.55n 0.0v 479.45n 0.0v 479.55n 0.0v 489.45n 0.0v 489.55n 3.3v 499.45n 3.3v 499.55n 0.0v 509.45n 0.0v 509.55n 0.0v 519.45n 0.0v 519.55n 0.0v 529.45n 0.0v 529.55n 0.0v 539.45n 0.0v 539.55n 0.0v 549.45n 0.0v 549.55n 0.0v 559.45n 0.0v 559.55n 0.0v 569.45n 0.0v 569.55n 0.0v 579.45n 0.0v 579.55n 0.0v 589.45n 0.0v 589.55n 3.3v 599.45n 3.3v 599.55n 0.0v 609.45n 0.0v 609.55n 3.3v 619.45n 3.3v 619.55n 3.3v 629.45n 3.3v 629.55n 3.3v 639.45n 3.3v 639.55n 3.3v 649.45n 3.3v 649.55n 3.3v 659.45n 3.3v 659.55n 3.3v 669.45n 3.3v 669.55n 3.3v 679.45n 3.3v 679.55n 3.3v 689.45n 3.3v 689.55n 3.3v 699.45n 3.3v 699.55n 3.3v 709.45n 3.3v 709.55n 0.0v 719.45n 0.0v 719.55n 0.0v 729.45n 0.0v 729.55n 0.0v 739.45n 0.0v 739.55n 3.3v 749.45n 3.3v 749.55n 3.3v 759.45n 3.3v 759.55n 0.0v 769.45n 0.0v 769.55n 0.0v 779.45n 0.0v 779.55n 0.0v 789.45n 0.0v 789.55n 0.0v 799.45n 0.0v 799.55n 0.0v 809.45n 0.0v 809.55n 3.3v 819.45n 3.3v 819.55n 3.3v 829.45n 3.3v 829.55n 3.3v 839.45n 3.3v 839.55n 3.3v 849.45n 3.3v 849.55n 0.0v 859.45n 0.0v 859.55n 3.3v 869.45n 3.3v 869.55n 3.3v 879.45n 3.3v 879.55n 3.3v 889.45n 3.3v 889.55n 3.3v 899.45n 3.3v 899.55n 0.0v 909.45n 0.0v 909.55n 0.0v 919.45n 0.0v 919.55n 3.3v 929.45n 3.3v 929.55n 3.3v 939.45n 3.3v 939.55n 3.3v 949.45n 3.3v 949.55n 3.3v 959.45n 3.3v 959.55n 0.0v 969.45n 0.0v 969.55n 3.3v 979.45n 3.3v 979.55n 3.3v 989.45n 3.3v 989.55n 3.3v 999.45n 3.3v 999.55n 0.0v 1009.45n 0.0v 1009.55n 3.3v 1019.45n 3.3v 1019.55n 3.3v 1029.45n 3.3v 1029.55n 3.3v 1039.45n 3.3v 1039.55n 3.3v 1049.45n 3.3v 1049.55n 3.3v 1059.45n 3.3v 1059.55n 0.0v 1069.45n 0.0v 1069.55n 0.0v 1079.45n 0.0v 1079.55n 3.3v 1089.45n 3.3v 1089.55n 3.3v 1099.45n 3.3v 1099.55n 0.0v 1109.45n 0.0v 1109.55n 0.0v 1119.45n 0.0v 1119.55n 0.0v 1129.45n 0.0v 1129.55n 0.0v 1139.45n 0.0v 1139.55n 3.3v 1149.45n 3.3v 1149.55n 3.3v 1159.45n 3.3v 1159.55n 3.3v 1169.45n 3.3v 1169.55n 0.0v 1179.45n 0.0v 1179.55n 0.0v 1189.45n 0.0v 1189.55n 3.3v 1199.45n 3.3v 1199.55n 3.3v 1209.45n 3.3v 1209.55n 3.3v 1219.45n 3.3v 1219.55n 0.0v 1229.45n 0.0v 1229.55n 3.3v 1239.45n 3.3v 1239.55n 3.3v 1249.45n 3.3v 1249.55n 3.3v 1259.45n 3.3v 1259.55n 0.0v 1269.45n 0.0v 1269.55n 3.3v 1279.45n 3.3v 1279.55n 0.0v 1289.45n 0.0v 1289.55n 0.0v 1299.45n 0.0v 1299.55n 3.3v 1309.45n 3.3v 1309.55n 0.0v 1319.45n 0.0v 1319.55n 0.0v 1329.45n 0.0v 1329.55n 3.3v 1339.45n 3.3v 1339.55n 3.3v 1349.45n 3.3v 1349.55n 3.3v 1359.45n 3.3v 1359.55n 0.0v 1369.45n 0.0v 1369.55n 0.0v 1379.45n 0.0v 1379.55n 0.0v 1389.45n 0.0v 1389.55n 3.3v 1399.45n 3.3v 1399.55n 3.3v 1409.45n 3.3v 1409.55n 0.0v 1419.45n 0.0v 1419.55n 0.0v 1429.45n 0.0v 1429.55n 0.0v 1439.45n 0.0v 1439.55n 3.3v 1449.45n 3.3v 1449.55n 3.3v 1459.45n 3.3v 1459.55n 0.0v 1469.45n 0.0v 1469.55n 3.3v 1479.45n 3.3v 1479.55n 3.3v 1489.45n 3.3v 1489.55n 3.3v 1499.45n 3.3v 1499.55n 3.3v 1509.45n 3.3v 1509.55n 0.0v 1519.45n 0.0v 1519.55n 3.3v 1529.45n 3.3v 1529.55n 3.3v 1539.45n 3.3v 1539.55n 0.0v 1549.45n 0.0v 1549.55n 0.0v 1559.45n 0.0v 1559.55n 3.3v 1569.45n 3.3v 1569.55n 3.3v 1579.45n 3.3v 1579.55n 0.0v 1589.45n 0.0v 1589.55n 0.0v 1599.45n 0.0v 1599.55n 3.3v 1609.45n 3.3v 1609.55n 3.3v 1619.45n 3.3v 1619.55n 3.3v 1629.45n 3.3v 1629.55n 3.3v 1639.45n 3.3v 1639.55n 3.3v 1649.45n 3.3v 1649.55n 0.0v 1659.45n 0.0v 1659.55n 0.0v 1669.45n 0.0v 1669.55n 3.3v 1679.45n 3.3v 1679.55n 3.3v 1689.45n 3.3v 1689.55n 3.3v 1699.45n 3.3v 1699.55n 3.3v 1709.45n 3.3v 1709.55n 3.3v 1719.45n 3.3v 1719.55n 0.0v 1729.45n 0.0v 1729.55n 3.3v 1739.45n 3.3v 1739.55n 0.0v 1749.45n 0.0v 1749.55n 3.3v 1759.45n 3.3v 1759.55n 3.3v 1769.45n 3.3v 1769.55n 3.3v 1779.45n 3.3v 1779.55n 3.3v 1789.45n 3.3v 1789.55n 3.3v 1799.45n 3.3v 1799.55n 0.0v 1809.45n 0.0v 1809.55n 3.3v 1819.45n 3.3v 1819.55n 0.0v 1829.45n 0.0v 1829.55n 3.3v 1839.45n 3.3v 1839.55n 3.3v 1849.45n 3.3v 1849.55n 3.3v 1859.45n 3.3v 1859.55n 3.3v 1869.45n 3.3v 1869.55n 0.0v 1879.45n 0.0v 1879.55n 0.0v 1889.45n 0.0v 1889.55n 0.0v 1899.45n 0.0v 1899.55n 0.0v 1909.45n 0.0v 1909.55n 0.0v 1919.45n 0.0v 1919.55n 0.0v 1929.45n 0.0v 1929.55n 0.0v 1939.45n 0.0v 1939.55n 0.0v 1949.45n 0.0v 1949.55n 0.0v 1959.45n 0.0v 1959.55n 3.3v 1969.45n 3.3v 1969.55n 3.3v 1979.45n 3.3v 1979.55n 0.0v 1989.45n 0.0v 1989.55n 3.3v 1999.45n 3.3v 1999.55n 0.0v 2009.45n 0.0v 2009.55n 3.3v 2019.45n 3.3v 2019.55n 3.3v 2029.45n 3.3v 2029.55n 3.3v 2039.45n 3.3v 2039.55n 3.3v 2049.45n 3.3v 2049.55n 3.3v )
* (time, data): [(0, 0), (10, 1), (20, 1), (30, 1), (40, 1), (50, 1), (60, 1), (70, 1), (80, 1), (90, 1), (100, 1), (110, 1), (120, 1), (130, 1), (140, 1), (150, 1), (160, 1), (170, 1), (180, 0), (190, 0), (200, 1), (210, 0), (220, 1), (230, 1), (240, 0), (250, 1), (260, 1), (270, 1), (280, 1), (290, 1), (300, 1), (310, 1), (320, 0), (330, 1), (340, 1), (350, 1), (360, 0), (370, 0), (380, 0), (390, 1), (400, 0), (410, 0), (420, 1), (430, 1), (440, 1), (450, 0), (460, 1), (470, 0), (480, 0), (490, 1), (500, 0), (510, 0), (520, 0), (530, 0), (540, 0), (550, 0), (560, 0), (570, 0), (580, 0), (590, 1), (600, 0), (610, 1), (620, 1), (630, 1), (640, 1), (650, 1), (660, 1), (670, 1), (680, 1), (690, 1), (700, 1), (710, 0), (720, 0), (730, 0), (740, 1), (750, 1), (760, 0), (770, 0), (780, 0), (790, 0), (800, 0), (810, 1), (820, 1), (830, 1), (840, 1), (850, 0), (860, 1), (870, 1), (880, 1), (890, 1), (900, 0), (910, 0), (920, 1), (930, 1), (940, 1), (950, 1), (960, 0), (970, 1), (980, 1), (990, 1), (1000, 0), (1010, 1), (1020, 1), (1030, 1), (1040, 1), (1050, 1), (1060, 0), (1070, 0), (1080, 1), (1090, 1), (1100, 0), (1110, 0), (1120, 0), (1130, 0), (1140, 1), (1150, 1), (1160, 1), (1170, 0), (1180, 0), (1190, 1), (1200, 1), (1210, 1), (1220, 0), (1230, 1), (1240, 1), (1250, 1), (1260, 0), (1270, 1), (1280, 0), (1290, 0), (1300, 1), (1310, 0), (1320, 0), (1330, 1), (1340, 1), (1350, 1), (1360, 0), (1370, 0), (1380, 0), (1390, 1), (1400, 1), (1410, 0), (1420, 0), (1430, 0), (1440, 1), (1450, 1), (1460, 0), (1470, 1), (1480, 1), (1490, 1), (1500, 1), (1510, 0), (1520, 1), (1530, 1), (1540, 0), (1550, 0), (1560, 1), (1570, 1), (1580, 0), (1590, 0), (1600, 1), (1610, 1), (1620, 1), (1630, 1), (1640, 1), (1650, 0), (1660, 0), (1670, 1), (1680, 1), (1690, 1), (1700, 1), (1710, 1), (1720, 0), (1730, 1), (1740, 0), (1750, 1), (1760, 1), (1770, 1), (1780, 1), (1790, 1), (1800, 0), (1810, 1), (1820, 0), (1830, 1), (1840, 1), (1850, 1), (1860, 1), (1870, 0), (1880, 0), (1890, 0), (1900, 0), (1910, 0), (1920, 0), (1930, 0), (1940, 0), (1950, 0), (1960, 1), (1970, 1), (1980, 0), (1990, 1), (2000, 0), (2010, 1), (2020, 1), (2030, 1), (2040, 1), (2050, 1)]
Va0_3  a0_3  0 PWL (0n 0.0v 9.45n 0.0v 9.55n 3.3v 19.45n 3.3v 19.55n 3.3v 29.45n 3.3v 29.55n 3.3v 39.45n 3.3v 39.55n 3.3v 49.45n 3.3v 49.55n 3.3v 59.45n 3.3v 59.55n 3.3v 69.45n 3.3v 69.55n 3.3v 79.45n 3.3v 79.55n 3.3v 89.45n 3.3v 89.55n 3.3v 99.45n 3.3v 99.55n 3.3v 109.45n 3.3v 109.55n 3.3v 119.45n 3.3v 119.55n 3.3v 129.45n 3.3v 129.55n 3.3v 139.45n 3.3v 139.55n 3.3v 149.45n 3.3v 149.55n 3.3v 159.45n 3.3v 159.55n 3.3v 169.45n 3.3v 169.55n 3.3v 179.45n 3.3v 179.55n 0.0v 189.45n 0.0v 189.55n 0.0v 199.45n 0.0v 199.55n 3.3v 209.45n 3.3v 209.55n 0.0v 219.45n 0.0v 219.55n 3.3v 229.45n 3.3v 229.55n 3.3v 239.45n 3.3v 239.55n 0.0v 249.45n 0.0v 249.55n 3.3v 259.45n 3.3v 259.55n 3.3v 269.45n 3.3v 269.55n 3.3v 279.45n 3.3v 279.55n 3.3v 289.45n 3.3v 289.55n 3.3v 299.45n 3.3v 299.55n 3.3v 309.45n 3.3v 309.55n 3.3v 319.45n 3.3v 319.55n 0.0v 329.45n 0.0v 329.55n 3.3v 339.45n 3.3v 339.55n 3.3v 349.45n 3.3v 349.55n 3.3v 359.45n 3.3v 359.55n 0.0v 369.45n 0.0v 369.55n 0.0v 379.45n 0.0v 379.55n 0.0v 389.45n 0.0v 389.55n 3.3v 399.45n 3.3v 399.55n 0.0v 409.45n 0.0v 409.55n 0.0v 419.45n 0.0v 419.55n 3.3v 429.45n 3.3v 429.55n 3.3v 439.45n 3.3v 439.55n 3.3v 449.45n 3.3v 449.55n 0.0v 459.45n 0.0v 459.55n 3.3v 469.45n 3.3v 469.55n 0.0v 479.45n 0.0v 479.55n 0.0v 489.45n 0.0v 489.55n 3.3v 499.45n 3.3v 499.55n 0.0v 509.45n 0.0v 509.55n 0.0v 519.45n 0.0v 519.55n 0.0v 529.45n 0.0v 529.55n 0.0v 539.45n 0.0v 539.55n 0.0v 549.45n 0.0v 549.55n 0.0v 559.45n 0.0v 559.55n 0.0v 569.45n 0.0v 569.55n 0.0v 579.45n 0.0v 579.55n 0.0v 589.45n 0.0v 589.55n 3.3v 599.45n 3.3v 599.55n 0.0v 609.45n 0.0v 609.55n 3.3v 619.45n 3.3v 619.55n 3.3v 629.45n 3.3v 629.55n 3.3v 639.45n 3.3v 639.55n 3.3v 649.45n 3.3v 649.55n 3.3v 659.45n 3.3v 659.55n 3.3v 669.45n 3.3v 669.55n 3.3v 679.45n 3.3v 679.55n 3.3v 689.45n 3.3v 689.55n 3.3v 699.45n 3.3v 699.55n 3.3v 709.45n 3.3v 709.55n 0.0v 719.45n 0.0v 719.55n 0.0v 729.45n 0.0v 729.55n 0.0v 739.45n 0.0v 739.55n 3.3v 749.45n 3.3v 749.55n 3.3v 759.45n 3.3v 759.55n 0.0v 769.45n 0.0v 769.55n 0.0v 779.45n 0.0v 779.55n 0.0v 789.45n 0.0v 789.55n 0.0v 799.45n 0.0v 799.55n 0.0v 809.45n 0.0v 809.55n 3.3v 819.45n 3.3v 819.55n 3.3v 829.45n 3.3v 829.55n 3.3v 839.45n 3.3v 839.55n 3.3v 849.45n 3.3v 849.55n 0.0v 859.45n 0.0v 859.55n 3.3v 869.45n 3.3v 869.55n 3.3v 879.45n 3.3v 879.55n 3.3v 889.45n 3.3v 889.55n 3.3v 899.45n 3.3v 899.55n 0.0v 909.45n 0.0v 909.55n 0.0v 919.45n 0.0v 919.55n 3.3v 929.45n 3.3v 929.55n 3.3v 939.45n 3.3v 939.55n 3.3v 949.45n 3.3v 949.55n 3.3v 959.45n 3.3v 959.55n 0.0v 969.45n 0.0v 969.55n 3.3v 979.45n 3.3v 979.55n 3.3v 989.45n 3.3v 989.55n 3.3v 999.45n 3.3v 999.55n 0.0v 1009.45n 0.0v 1009.55n 3.3v 1019.45n 3.3v 1019.55n 3.3v 1029.45n 3.3v 1029.55n 3.3v 1039.45n 3.3v 1039.55n 3.3v 1049.45n 3.3v 1049.55n 3.3v 1059.45n 3.3v 1059.55n 0.0v 1069.45n 0.0v 1069.55n 0.0v 1079.45n 0.0v 1079.55n 3.3v 1089.45n 3.3v 1089.55n 3.3v 1099.45n 3.3v 1099.55n 0.0v 1109.45n 0.0v 1109.55n 0.0v 1119.45n 0.0v 1119.55n 0.0v 1129.45n 0.0v 1129.55n 0.0v 1139.45n 0.0v 1139.55n 3.3v 1149.45n 3.3v 1149.55n 3.3v 1159.45n 3.3v 1159.55n 3.3v 1169.45n 3.3v 1169.55n 0.0v 1179.45n 0.0v 1179.55n 0.0v 1189.45n 0.0v 1189.55n 3.3v 1199.45n 3.3v 1199.55n 3.3v 1209.45n 3.3v 1209.55n 3.3v 1219.45n 3.3v 1219.55n 0.0v 1229.45n 0.0v 1229.55n 3.3v 1239.45n 3.3v 1239.55n 3.3v 1249.45n 3.3v 1249.55n 3.3v 1259.45n 3.3v 1259.55n 0.0v 1269.45n 0.0v 1269.55n 3.3v 1279.45n 3.3v 1279.55n 0.0v 1289.45n 0.0v 1289.55n 0.0v 1299.45n 0.0v 1299.55n 3.3v 1309.45n 3.3v 1309.55n 0.0v 1319.45n 0.0v 1319.55n 0.0v 1329.45n 0.0v 1329.55n 3.3v 1339.45n 3.3v 1339.55n 3.3v 1349.45n 3.3v 1349.55n 3.3v 1359.45n 3.3v 1359.55n 0.0v 1369.45n 0.0v 1369.55n 0.0v 1379.45n 0.0v 1379.55n 0.0v 1389.45n 0.0v 1389.55n 3.3v 1399.45n 3.3v 1399.55n 3.3v 1409.45n 3.3v 1409.55n 0.0v 1419.45n 0.0v 1419.55n 0.0v 1429.45n 0.0v 1429.55n 0.0v 1439.45n 0.0v 1439.55n 3.3v 1449.45n 3.3v 1449.55n 3.3v 1459.45n 3.3v 1459.55n 0.0v 1469.45n 0.0v 1469.55n 3.3v 1479.45n 3.3v 1479.55n 3.3v 1489.45n 3.3v 1489.55n 3.3v 1499.45n 3.3v 1499.55n 3.3v 1509.45n 3.3v 1509.55n 0.0v 1519.45n 0.0v 1519.55n 3.3v 1529.45n 3.3v 1529.55n 3.3v 1539.45n 3.3v 1539.55n 0.0v 1549.45n 0.0v 1549.55n 0.0v 1559.45n 0.0v 1559.55n 3.3v 1569.45n 3.3v 1569.55n 3.3v 1579.45n 3.3v 1579.55n 0.0v 1589.45n 0.0v 1589.55n 0.0v 1599.45n 0.0v 1599.55n 3.3v 1609.45n 3.3v 1609.55n 3.3v 1619.45n 3.3v 1619.55n 3.3v 1629.45n 3.3v 1629.55n 3.3v 1639.45n 3.3v 1639.55n 3.3v 1649.45n 3.3v 1649.55n 0.0v 1659.45n 0.0v 1659.55n 0.0v 1669.45n 0.0v 1669.55n 3.3v 1679.45n 3.3v 1679.55n 3.3v 1689.45n 3.3v 1689.55n 3.3v 1699.45n 3.3v 1699.55n 3.3v 1709.45n 3.3v 1709.55n 3.3v 1719.45n 3.3v 1719.55n 0.0v 1729.45n 0.0v 1729.55n 3.3v 1739.45n 3.3v 1739.55n 0.0v 1749.45n 0.0v 1749.55n 3.3v 1759.45n 3.3v 1759.55n 3.3v 1769.45n 3.3v 1769.55n 3.3v 1779.45n 3.3v 1779.55n 3.3v 1789.45n 3.3v 1789.55n 3.3v 1799.45n 3.3v 1799.55n 0.0v 1809.45n 0.0v 1809.55n 3.3v 1819.45n 3.3v 1819.55n 0.0v 1829.45n 0.0v 1829.55n 3.3v 1839.45n 3.3v 1839.55n 3.3v 1849.45n 3.3v 1849.55n 3.3v 1859.45n 3.3v 1859.55n 3.3v 1869.45n 3.3v 1869.55n 0.0v 1879.45n 0.0v 1879.55n 0.0v 1889.45n 0.0v 1889.55n 0.0v 1899.45n 0.0v 1899.55n 0.0v 1909.45n 0.0v 1909.55n 0.0v 1919.45n 0.0v 1919.55n 0.0v 1929.45n 0.0v 1929.55n 0.0v 1939.45n 0.0v 1939.55n 0.0v 1949.45n 0.0v 1949.55n 0.0v 1959.45n 0.0v 1959.55n 3.3v 1969.45n 3.3v 1969.55n 3.3v 1979.45n 3.3v 1979.55n 0.0v 1989.45n 0.0v 1989.55n 3.3v 1999.45n 3.3v 1999.55n 0.0v 2009.45n 0.0v 2009.55n 3.3v 2019.45n 3.3v 2019.55n 3.3v 2029.45n 3.3v 2029.55n 3.3v 2039.45n 3.3v 2039.55n 3.3v 2049.45n 3.3v 2049.55n 3.3v )

 * Generation of control signals
* (time, data): [(0, 1), (10, 0), (20, 0), (30, 0), (40, 0), (50, 0), (60, 1), (70, 0), (80, 0), (90, 0), (100, 0), (110, 0), (120, 0), (130, 0), (140, 0), (150, 1), (160, 0), (170, 0), (180, 0), (190, 0), (200, 0), (210, 0), (220, 0), (230, 1), (240, 0), (250, 0), (260, 0), (270, 1), (280, 0), (290, 1), (300, 0), (310, 0), (320, 0), (330, 0), (340, 1), (350, 0), (360, 0), (370, 1), (380, 0), (390, 0), (400, 0), (410, 1), (420, 0), (430, 1), (440, 1), (450, 0), (460, 0), (470, 0), (480, 0), (490, 0), (500, 0), (510, 1), (520, 0), (530, 0), (540, 0), (550, 0), (560, 1), (570, 1), (580, 0), (590, 0), (600, 0), (610, 0), (620, 1), (630, 1), (640, 1), (650, 0), (660, 0), (670, 1), (680, 1), (690, 0), (700, 0), (710, 0), (720, 1), (730, 0), (740, 0), (750, 0), (760, 0), (770, 1), (780, 1), (790, 0), (800, 0), (810, 0), (820, 0), (830, 1), (840, 1), (850, 0), (860, 0), (870, 1), (880, 0), (890, 0), (900, 0), (910, 1), (920, 0), (930, 0), (940, 1), (950, 0), (960, 0), (970, 0), (980, 0), (990, 0), (1000, 0), (1010, 0), (1020, 1), (1030, 0), (1040, 0), (1050, 1), (1060, 0), (1070, 0), (1080, 0), (1090, 0), (1100, 0), (1110, 0), (1120, 1), (1130, 0), (1140, 0), (1150, 0), (1160, 0), (1170, 0), (1180, 0), (1190, 0), (1200, 0), (1210, 0), (1220, 0), (1230, 0), (1240, 1), (1250, 0), (1260, 0), (1270, 0), (1280, 0), (1290, 1), (1300, 0), (1310, 0), (1320, 1), (1330, 0), (1340, 0), (1350, 0), (1360, 0), (1370, 1), (1380, 1), (1390, 0), (1400, 0), (1410, 0), (1420, 1), (1430, 1), (1440, 0), (1450, 1), (1460, 0), (1470, 0), (1480, 0), (1490, 1), (1500, 1), (1510, 0), (1520, 0), (1530, 0), (1540, 0), (1550, 0), (1560, 0), (1570, 1), (1580, 0), (1590, 1), (1600, 0), (1610, 0), (1620, 0), (1630, 0), (1640, 0), (1650, 0), (1660, 0), (1670, 0), (1680, 0), (1690, 0), (1700, 0), (1710, 0), (1720, 0), (1730, 0), (1740, 0), (1750, 0), (1760, 0), (1770, 1), (1780, 1), (1790, 0), (1800, 0), (1810, 0), (1820, 0), (1830, 0), (1840, 0), (1850, 0), (1860, 1), (1870, 0), (1880, 1), (1890, 1), (1900, 0), (1910, 0), (1920, 1), (1930, 0), (1940, 0), (1950, 0), (1960, 0), (1970, 0), (1980, 0), (1990, 0), (2000, 0), (2010, 0), (2020, 1), (2030, 0), (2040, 0), (2050, 1)]
VCSB0 CSB0 0 PWL (0n 3.3v 9.45n 3.3v 9.55n 0.0v 19.45n 0.0v 19.55n 0.0v 29.45n 0.0v 29.55n 0.0v 39.45n 0.0v 39.55n 0.0v 49.45n 0.0v 49.55n 0.0v 59.45n 0.0v 59.55n 3.3v 69.45n 3.3v 69.55n 0.0v 79.45n 0.0v 79.55n 0.0v 89.45n 0.0v 89.55n 0.0v 99.45n 0.0v 99.55n 0.0v 109.45n 0.0v 109.55n 0.0v 119.45n 0.0v 119.55n 0.0v 129.45n 0.0v 129.55n 0.0v 139.45n 0.0v 139.55n 0.0v 149.45n 0.0v 149.55n 3.3v 159.45n 3.3v 159.55n 0.0v 169.45n 0.0v 169.55n 0.0v 179.45n 0.0v 179.55n 0.0v 189.45n 0.0v 189.55n 0.0v 199.45n 0.0v 199.55n 0.0v 209.45n 0.0v 209.55n 0.0v 219.45n 0.0v 219.55n 0.0v 229.45n 0.0v 229.55n 3.3v 239.45n 3.3v 239.55n 0.0v 249.45n 0.0v 249.55n 0.0v 259.45n 0.0v 259.55n 0.0v 269.45n 0.0v 269.55n 3.3v 279.45n 3.3v 279.55n 0.0v 289.45n 0.0v 289.55n 3.3v 299.45n 3.3v 299.55n 0.0v 309.45n 0.0v 309.55n 0.0v 319.45n 0.0v 319.55n 0.0v 329.45n 0.0v 329.55n 0.0v 339.45n 0.0v 339.55n 3.3v 349.45n 3.3v 349.55n 0.0v 359.45n 0.0v 359.55n 0.0v 369.45n 0.0v 369.55n 3.3v 379.45n 3.3v 379.55n 0.0v 389.45n 0.0v 389.55n 0.0v 399.45n 0.0v 399.55n 0.0v 409.45n 0.0v 409.55n 3.3v 419.45n 3.3v 419.55n 0.0v 429.45n 0.0v 429.55n 3.3v 439.45n 3.3v 439.55n 3.3v 449.45n 3.3v 449.55n 0.0v 459.45n 0.0v 459.55n 0.0v 469.45n 0.0v 469.55n 0.0v 479.45n 0.0v 479.55n 0.0v 489.45n 0.0v 489.55n 0.0v 499.45n 0.0v 499.55n 0.0v 509.45n 0.0v 509.55n 3.3v 519.45n 3.3v 519.55n 0.0v 529.45n 0.0v 529.55n 0.0v 539.45n 0.0v 539.55n 0.0v 549.45n 0.0v 549.55n 0.0v 559.45n 0.0v 559.55n 3.3v 569.45n 3.3v 569.55n 3.3v 579.45n 3.3v 579.55n 0.0v 589.45n 0.0v 589.55n 0.0v 599.45n 0.0v 599.55n 0.0v 609.45n 0.0v 609.55n 0.0v 619.45n 0.0v 619.55n 3.3v 629.45n 3.3v 629.55n 3.3v 639.45n 3.3v 639.55n 3.3v 649.45n 3.3v 649.55n 0.0v 659.45n 0.0v 659.55n 0.0v 669.45n 0.0v 669.55n 3.3v 679.45n 3.3v 679.55n 3.3v 689.45n 3.3v 689.55n 0.0v 699.45n 0.0v 699.55n 0.0v 709.45n 0.0v 709.55n 0.0v 719.45n 0.0v 719.55n 3.3v 729.45n 3.3v 729.55n 0.0v 739.45n 0.0v 739.55n 0.0v 749.45n 0.0v 749.55n 0.0v 759.45n 0.0v 759.55n 0.0v 769.45n 0.0v 769.55n 3.3v 779.45n 3.3v 779.55n 3.3v 789.45n 3.3v 789.55n 0.0v 799.45n 0.0v 799.55n 0.0v 809.45n 0.0v 809.55n 0.0v 819.45n 0.0v 819.55n 0.0v 829.45n 0.0v 829.55n 3.3v 839.45n 3.3v 839.55n 3.3v 849.45n 3.3v 849.55n 0.0v 859.45n 0.0v 859.55n 0.0v 869.45n 0.0v 869.55n 3.3v 879.45n 3.3v 879.55n 0.0v 889.45n 0.0v 889.55n 0.0v 899.45n 0.0v 899.55n 0.0v 909.45n 0.0v 909.55n 3.3v 919.45n 3.3v 919.55n 0.0v 929.45n 0.0v 929.55n 0.0v 939.45n 0.0v 939.55n 3.3v 949.45n 3.3v 949.55n 0.0v 959.45n 0.0v 959.55n 0.0v 969.45n 0.0v 969.55n 0.0v 979.45n 0.0v 979.55n 0.0v 989.45n 0.0v 989.55n 0.0v 999.45n 0.0v 999.55n 0.0v 1009.45n 0.0v 1009.55n 0.0v 1019.45n 0.0v 1019.55n 3.3v 1029.45n 3.3v 1029.55n 0.0v 1039.45n 0.0v 1039.55n 0.0v 1049.45n 0.0v 1049.55n 3.3v 1059.45n 3.3v 1059.55n 0.0v 1069.45n 0.0v 1069.55n 0.0v 1079.45n 0.0v 1079.55n 0.0v 1089.45n 0.0v 1089.55n 0.0v 1099.45n 0.0v 1099.55n 0.0v 1109.45n 0.0v 1109.55n 0.0v 1119.45n 0.0v 1119.55n 3.3v 1129.45n 3.3v 1129.55n 0.0v 1139.45n 0.0v 1139.55n 0.0v 1149.45n 0.0v 1149.55n 0.0v 1159.45n 0.0v 1159.55n 0.0v 1169.45n 0.0v 1169.55n 0.0v 1179.45n 0.0v 1179.55n 0.0v 1189.45n 0.0v 1189.55n 0.0v 1199.45n 0.0v 1199.55n 0.0v 1209.45n 0.0v 1209.55n 0.0v 1219.45n 0.0v 1219.55n 0.0v 1229.45n 0.0v 1229.55n 0.0v 1239.45n 0.0v 1239.55n 3.3v 1249.45n 3.3v 1249.55n 0.0v 1259.45n 0.0v 1259.55n 0.0v 1269.45n 0.0v 1269.55n 0.0v 1279.45n 0.0v 1279.55n 0.0v 1289.45n 0.0v 1289.55n 3.3v 1299.45n 3.3v 1299.55n 0.0v 1309.45n 0.0v 1309.55n 0.0v 1319.45n 0.0v 1319.55n 3.3v 1329.45n 3.3v 1329.55n 0.0v 1339.45n 0.0v 1339.55n 0.0v 1349.45n 0.0v 1349.55n 0.0v 1359.45n 0.0v 1359.55n 0.0v 1369.45n 0.0v 1369.55n 3.3v 1379.45n 3.3v 1379.55n 3.3v 1389.45n 3.3v 1389.55n 0.0v 1399.45n 0.0v 1399.55n 0.0v 1409.45n 0.0v 1409.55n 0.0v 1419.45n 0.0v 1419.55n 3.3v 1429.45n 3.3v 1429.55n 3.3v 1439.45n 3.3v 1439.55n 0.0v 1449.45n 0.0v 1449.55n 3.3v 1459.45n 3.3v 1459.55n 0.0v 1469.45n 0.0v 1469.55n 0.0v 1479.45n 0.0v 1479.55n 0.0v 1489.45n 0.0v 1489.55n 3.3v 1499.45n 3.3v 1499.55n 3.3v 1509.45n 3.3v 1509.55n 0.0v 1519.45n 0.0v 1519.55n 0.0v 1529.45n 0.0v 1529.55n 0.0v 1539.45n 0.0v 1539.55n 0.0v 1549.45n 0.0v 1549.55n 0.0v 1559.45n 0.0v 1559.55n 0.0v 1569.45n 0.0v 1569.55n 3.3v 1579.45n 3.3v 1579.55n 0.0v 1589.45n 0.0v 1589.55n 3.3v 1599.45n 3.3v 1599.55n 0.0v 1609.45n 0.0v 1609.55n 0.0v 1619.45n 0.0v 1619.55n 0.0v 1629.45n 0.0v 1629.55n 0.0v 1639.45n 0.0v 1639.55n 0.0v 1649.45n 0.0v 1649.55n 0.0v 1659.45n 0.0v 1659.55n 0.0v 1669.45n 0.0v 1669.55n 0.0v 1679.45n 0.0v 1679.55n 0.0v 1689.45n 0.0v 1689.55n 0.0v 1699.45n 0.0v 1699.55n 0.0v 1709.45n 0.0v 1709.55n 0.0v 1719.45n 0.0v 1719.55n 0.0v 1729.45n 0.0v 1729.55n 0.0v 1739.45n 0.0v 1739.55n 0.0v 1749.45n 0.0v 1749.55n 0.0v 1759.45n 0.0v 1759.55n 0.0v 1769.45n 0.0v 1769.55n 3.3v 1779.45n 3.3v 1779.55n 3.3v 1789.45n 3.3v 1789.55n 0.0v 1799.45n 0.0v 1799.55n 0.0v 1809.45n 0.0v 1809.55n 0.0v 1819.45n 0.0v 1819.55n 0.0v 1829.45n 0.0v 1829.55n 0.0v 1839.45n 0.0v 1839.55n 0.0v 1849.45n 0.0v 1849.55n 0.0v 1859.45n 0.0v 1859.55n 3.3v 1869.45n 3.3v 1869.55n 0.0v 1879.45n 0.0v 1879.55n 3.3v 1889.45n 3.3v 1889.55n 3.3v 1899.45n 3.3v 1899.55n 0.0v 1909.45n 0.0v 1909.55n 0.0v 1919.45n 0.0v 1919.55n 3.3v 1929.45n 3.3v 1929.55n 0.0v 1939.45n 0.0v 1939.55n 0.0v 1949.45n 0.0v 1949.55n 0.0v 1959.45n 0.0v 1959.55n 0.0v 1969.45n 0.0v 1969.55n 0.0v 1979.45n 0.0v 1979.55n 0.0v 1989.45n 0.0v 1989.55n 0.0v 1999.45n 0.0v 1999.55n 0.0v 2009.45n 0.0v 2009.55n 0.0v 2019.45n 0.0v 2019.55n 3.3v 2029.45n 3.3v 2029.55n 0.0v 2039.45n 0.0v 2039.55n 0.0v 2049.45n 0.0v 2049.55n 3.3v )
* (time, data): [(0, 1), (10, 0), (20, 0), (30, 0), (40, 1), (50, 0), (60, 1), (70, 1), (80, 1), (90, 0), (100, 1), (110, 1), (120, 0), (130, 1), (140, 1), (150, 1), (160, 0), (170, 1), (180, 0), (190, 1), (200, 1), (210, 1), (220, 1), (230, 1), (240, 0), (250, 0), (260, 1), (270, 1), (280, 1), (290, 1), (300, 1), (310, 0), (320, 1), (330, 1), (340, 1), (350, 1), (360, 1), (370, 1), (380, 0), (390, 0), (400, 1), (410, 1), (420, 0), (430, 1), (440, 1), (450, 1), (460, 1), (470, 1), (480, 1), (490, 1), (500, 1), (510, 1), (520, 1), (530, 1), (540, 0), (550, 0), (560, 1), (570, 1), (580, 0), (590, 0), (600, 0), (610, 0), (620, 1), (630, 1), (640, 1), (650, 1), (660, 1), (670, 1), (680, 1), (690, 0), (700, 0), (710, 1), (720, 1), (730, 1), (740, 1), (750, 1), (760, 1), (770, 1), (780, 1), (790, 0), (800, 0), (810, 1), (820, 1), (830, 1), (840, 1), (850, 1), (860, 1), (870, 1), (880, 1), (890, 1), (900, 0), (910, 1), (920, 1), (930, 1), (940, 1), (950, 1), (960, 1), (970, 1), (980, 0), (990, 1), (1000, 0), (1010, 1), (1020, 1), (1030, 0), (1040, 0), (1050, 1), (1060, 0), (1070, 1), (1080, 0), (1090, 1), (1100, 1), (1110, 1), (1120, 1), (1130, 0), (1140, 0), (1150, 0), (1160, 0), (1170, 0), (1180, 0), (1190, 1), (1200, 1), (1210, 1), (1220, 1), (1230, 1), (1240, 1), (1250, 1), (1260, 1), (1270, 1), (1280, 0), (1290, 1), (1300, 0), (1310, 1), (1320, 1), (1330, 0), (1340, 0), (1350, 1), (1360, 1), (1370, 1), (1380, 1), (1390, 1), (1400, 0), (1410, 0), (1420, 1), (1430, 1), (1440, 0), (1450, 1), (1460, 0), (1470, 1), (1480, 0), (1490, 1), (1500, 1), (1510, 1), (1520, 1), (1530, 1), (1540, 0), (1550, 0), (1560, 1), (1570, 1), (1580, 1), (1590, 1), (1600, 0), (1610, 1), (1620, 0), (1630, 1), (1640, 1), (1650, 1), (1660, 0), (1670, 0), (1680, 1), (1690, 1), (1700, 1), (1710, 1), (1720, 1), (1730, 1), (1740, 0), (1750, 1), (1760, 1), (1770, 1), (1780, 1), (1790, 1), (1800, 1), (1810, 1), (1820, 0), (1830, 1), (1840, 1), (1850, 0), (1860, 1), (1870, 1), (1880, 1), (1890, 1), (1900, 1), (1910, 0), (1920, 1), (1930, 1), (1940, 0), (1950, 1), (1960, 1), (1970, 1), (1980, 1), (1990, 1), (2000, 1), (2010, 1), (2020, 1), (2030, 0), (2040, 1), (2050, 1)]
VWEB0 WEB0 0 PWL (0n 3.3v 9.45n 3.3v 9.55n 0.0v 19.45n 0.0v 19.55n 0.0v 29.45n 0.0v 29.55n 0.0v 39.45n 0.0v 39.55n 3.3v 49.45n 3.3v 49.55n 0.0v 59.45n 0.0v 59.55n 3.3v 69.45n 3.3v 69.55n 3.3v 79.45n 3.3v 79.55n 3.3v 89.45n 3.3v 89.55n 0.0v 99.45n 0.0v 99.55n 3.3v 109.45n 3.3v 109.55n 3.3v 119.45n 3.3v 119.55n 0.0v 129.45n 0.0v 129.55n 3.3v 139.45n 3.3v 139.55n 3.3v 149.45n 3.3v 149.55n 3.3v 159.45n 3.3v 159.55n 0.0v 169.45n 0.0v 169.55n 3.3v 179.45n 3.3v 179.55n 0.0v 189.45n 0.0v 189.55n 3.3v 199.45n 3.3v 199.55n 3.3v 209.45n 3.3v 209.55n 3.3v 219.45n 3.3v 219.55n 3.3v 229.45n 3.3v 229.55n 3.3v 239.45n 3.3v 239.55n 0.0v 249.45n 0.0v 249.55n 0.0v 259.45n 0.0v 259.55n 3.3v 269.45n 3.3v 269.55n 3.3v 279.45n 3.3v 279.55n 3.3v 289.45n 3.3v 289.55n 3.3v 299.45n 3.3v 299.55n 3.3v 309.45n 3.3v 309.55n 0.0v 319.45n 0.0v 319.55n 3.3v 329.45n 3.3v 329.55n 3.3v 339.45n 3.3v 339.55n 3.3v 349.45n 3.3v 349.55n 3.3v 359.45n 3.3v 359.55n 3.3v 369.45n 3.3v 369.55n 3.3v 379.45n 3.3v 379.55n 0.0v 389.45n 0.0v 389.55n 0.0v 399.45n 0.0v 399.55n 3.3v 409.45n 3.3v 409.55n 3.3v 419.45n 3.3v 419.55n 0.0v 429.45n 0.0v 429.55n 3.3v 439.45n 3.3v 439.55n 3.3v 449.45n 3.3v 449.55n 3.3v 459.45n 3.3v 459.55n 3.3v 469.45n 3.3v 469.55n 3.3v 479.45n 3.3v 479.55n 3.3v 489.45n 3.3v 489.55n 3.3v 499.45n 3.3v 499.55n 3.3v 509.45n 3.3v 509.55n 3.3v 519.45n 3.3v 519.55n 3.3v 529.45n 3.3v 529.55n 3.3v 539.45n 3.3v 539.55n 0.0v 549.45n 0.0v 549.55n 0.0v 559.45n 0.0v 559.55n 3.3v 569.45n 3.3v 569.55n 3.3v 579.45n 3.3v 579.55n 0.0v 589.45n 0.0v 589.55n 0.0v 599.45n 0.0v 599.55n 0.0v 609.45n 0.0v 609.55n 0.0v 619.45n 0.0v 619.55n 3.3v 629.45n 3.3v 629.55n 3.3v 639.45n 3.3v 639.55n 3.3v 649.45n 3.3v 649.55n 3.3v 659.45n 3.3v 659.55n 3.3v 669.45n 3.3v 669.55n 3.3v 679.45n 3.3v 679.55n 3.3v 689.45n 3.3v 689.55n 0.0v 699.45n 0.0v 699.55n 0.0v 709.45n 0.0v 709.55n 3.3v 719.45n 3.3v 719.55n 3.3v 729.45n 3.3v 729.55n 3.3v 739.45n 3.3v 739.55n 3.3v 749.45n 3.3v 749.55n 3.3v 759.45n 3.3v 759.55n 3.3v 769.45n 3.3v 769.55n 3.3v 779.45n 3.3v 779.55n 3.3v 789.45n 3.3v 789.55n 0.0v 799.45n 0.0v 799.55n 0.0v 809.45n 0.0v 809.55n 3.3v 819.45n 3.3v 819.55n 3.3v 829.45n 3.3v 829.55n 3.3v 839.45n 3.3v 839.55n 3.3v 849.45n 3.3v 849.55n 3.3v 859.45n 3.3v 859.55n 3.3v 869.45n 3.3v 869.55n 3.3v 879.45n 3.3v 879.55n 3.3v 889.45n 3.3v 889.55n 3.3v 899.45n 3.3v 899.55n 0.0v 909.45n 0.0v 909.55n 3.3v 919.45n 3.3v 919.55n 3.3v 929.45n 3.3v 929.55n 3.3v 939.45n 3.3v 939.55n 3.3v 949.45n 3.3v 949.55n 3.3v 959.45n 3.3v 959.55n 3.3v 969.45n 3.3v 969.55n 3.3v 979.45n 3.3v 979.55n 0.0v 989.45n 0.0v 989.55n 3.3v 999.45n 3.3v 999.55n 0.0v 1009.45n 0.0v 1009.55n 3.3v 1019.45n 3.3v 1019.55n 3.3v 1029.45n 3.3v 1029.55n 0.0v 1039.45n 0.0v 1039.55n 0.0v 1049.45n 0.0v 1049.55n 3.3v 1059.45n 3.3v 1059.55n 0.0v 1069.45n 0.0v 1069.55n 3.3v 1079.45n 3.3v 1079.55n 0.0v 1089.45n 0.0v 1089.55n 3.3v 1099.45n 3.3v 1099.55n 3.3v 1109.45n 3.3v 1109.55n 3.3v 1119.45n 3.3v 1119.55n 3.3v 1129.45n 3.3v 1129.55n 0.0v 1139.45n 0.0v 1139.55n 0.0v 1149.45n 0.0v 1149.55n 0.0v 1159.45n 0.0v 1159.55n 0.0v 1169.45n 0.0v 1169.55n 0.0v 1179.45n 0.0v 1179.55n 0.0v 1189.45n 0.0v 1189.55n 3.3v 1199.45n 3.3v 1199.55n 3.3v 1209.45n 3.3v 1209.55n 3.3v 1219.45n 3.3v 1219.55n 3.3v 1229.45n 3.3v 1229.55n 3.3v 1239.45n 3.3v 1239.55n 3.3v 1249.45n 3.3v 1249.55n 3.3v 1259.45n 3.3v 1259.55n 3.3v 1269.45n 3.3v 1269.55n 3.3v 1279.45n 3.3v 1279.55n 0.0v 1289.45n 0.0v 1289.55n 3.3v 1299.45n 3.3v 1299.55n 0.0v 1309.45n 0.0v 1309.55n 3.3v 1319.45n 3.3v 1319.55n 3.3v 1329.45n 3.3v 1329.55n 0.0v 1339.45n 0.0v 1339.55n 0.0v 1349.45n 0.0v 1349.55n 3.3v 1359.45n 3.3v 1359.55n 3.3v 1369.45n 3.3v 1369.55n 3.3v 1379.45n 3.3v 1379.55n 3.3v 1389.45n 3.3v 1389.55n 3.3v 1399.45n 3.3v 1399.55n 0.0v 1409.45n 0.0v 1409.55n 0.0v 1419.45n 0.0v 1419.55n 3.3v 1429.45n 3.3v 1429.55n 3.3v 1439.45n 3.3v 1439.55n 0.0v 1449.45n 0.0v 1449.55n 3.3v 1459.45n 3.3v 1459.55n 0.0v 1469.45n 0.0v 1469.55n 3.3v 1479.45n 3.3v 1479.55n 0.0v 1489.45n 0.0v 1489.55n 3.3v 1499.45n 3.3v 1499.55n 3.3v 1509.45n 3.3v 1509.55n 3.3v 1519.45n 3.3v 1519.55n 3.3v 1529.45n 3.3v 1529.55n 3.3v 1539.45n 3.3v 1539.55n 0.0v 1549.45n 0.0v 1549.55n 0.0v 1559.45n 0.0v 1559.55n 3.3v 1569.45n 3.3v 1569.55n 3.3v 1579.45n 3.3v 1579.55n 3.3v 1589.45n 3.3v 1589.55n 3.3v 1599.45n 3.3v 1599.55n 0.0v 1609.45n 0.0v 1609.55n 3.3v 1619.45n 3.3v 1619.55n 0.0v 1629.45n 0.0v 1629.55n 3.3v 1639.45n 3.3v 1639.55n 3.3v 1649.45n 3.3v 1649.55n 3.3v 1659.45n 3.3v 1659.55n 0.0v 1669.45n 0.0v 1669.55n 0.0v 1679.45n 0.0v 1679.55n 3.3v 1689.45n 3.3v 1689.55n 3.3v 1699.45n 3.3v 1699.55n 3.3v 1709.45n 3.3v 1709.55n 3.3v 1719.45n 3.3v 1719.55n 3.3v 1729.45n 3.3v 1729.55n 3.3v 1739.45n 3.3v 1739.55n 0.0v 1749.45n 0.0v 1749.55n 3.3v 1759.45n 3.3v 1759.55n 3.3v 1769.45n 3.3v 1769.55n 3.3v 1779.45n 3.3v 1779.55n 3.3v 1789.45n 3.3v 1789.55n 3.3v 1799.45n 3.3v 1799.55n 3.3v 1809.45n 3.3v 1809.55n 3.3v 1819.45n 3.3v 1819.55n 0.0v 1829.45n 0.0v 1829.55n 3.3v 1839.45n 3.3v 1839.55n 3.3v 1849.45n 3.3v 1849.55n 0.0v 1859.45n 0.0v 1859.55n 3.3v 1869.45n 3.3v 1869.55n 3.3v 1879.45n 3.3v 1879.55n 3.3v 1889.45n 3.3v 1889.55n 3.3v 1899.45n 3.3v 1899.55n 3.3v 1909.45n 3.3v 1909.55n 0.0v 1919.45n 0.0v 1919.55n 3.3v 1929.45n 3.3v 1929.55n 3.3v 1939.45n 3.3v 1939.55n 0.0v 1949.45n 0.0v 1949.55n 3.3v 1959.45n 3.3v 1959.55n 3.3v 1969.45n 3.3v 1969.55n 3.3v 1979.45n 3.3v 1979.55n 3.3v 1989.45n 3.3v 1989.55n 3.3v 1999.45n 3.3v 1999.55n 3.3v 2009.45n 3.3v 2009.55n 3.3v 2019.45n 3.3v 2019.55n 3.3v 2029.45n 3.3v 2029.55n 0.0v 2039.45n 0.0v 2039.55n 3.3v 2049.45n 3.3v 2049.55n 3.3v )
* PULSE: period=10
Vclk0 clk0 0 PULSE (0 3.3 9.95n 0.1n 0.1n 4.9n 10n)

 * Generation of dout measurements
* CHECK dout0_0 vdout0_0ck4 = 0 time = 50
* CHECK dout0_1 vdout0_1ck4 = 3.3 time = 50
* CHECK dout0_0 vdout0_0ck7 = 3.3 time = 80
* CHECK dout0_1 vdout0_1ck7 = 0 time = 80
* CHECK dout0_0 vdout0_0ck8 = 3.3 time = 90
* CHECK dout0_1 vdout0_1ck8 = 0 time = 90
* CHECK dout0_0 vdout0_0ck10 = 3.3 time = 110
* CHECK dout0_1 vdout0_1ck10 = 3.3 time = 110
* CHECK dout0_0 vdout0_0ck11 = 3.3 time = 120
* CHECK dout0_1 vdout0_1ck11 = 3.3 time = 120
* CHECK dout0_0 vdout0_0ck13 = 3.3 time = 140
* CHECK dout0_1 vdout0_1ck13 = 0 time = 140
* CHECK dout0_0 vdout0_0ck14 = 3.3 time = 150
* CHECK dout0_1 vdout0_1ck14 = 0 time = 150
* CHECK dout0_0 vdout0_0ck17 = 3.3 time = 180
* CHECK dout0_1 vdout0_1ck17 = 3.3 time = 180
* CHECK dout0_0 vdout0_0ck19 = 3.3 time = 200
* CHECK dout0_1 vdout0_1ck19 = 0 time = 200
* CHECK dout0_0 vdout0_0ck20 = 3.3 time = 210
* CHECK dout0_1 vdout0_1ck20 = 3.3 time = 210
* CHECK dout0_0 vdout0_0ck21 = 3.3 time = 220
* CHECK dout0_1 vdout0_1ck21 = 0 time = 220
* CHECK dout0_0 vdout0_0ck22 = 3.3 time = 230
* CHECK dout0_1 vdout0_1ck22 = 3.3 time = 230
* CHECK dout0_0 vdout0_0ck26 = 0 time = 270
* CHECK dout0_1 vdout0_1ck26 = 3.3 time = 270
* CHECK dout0_0 vdout0_0ck28 = 0 time = 290
* CHECK dout0_1 vdout0_1ck28 = 3.3 time = 290
* CHECK dout0_0 vdout0_0ck30 = 0 time = 310
* CHECK dout0_1 vdout0_1ck30 = 3.3 time = 310
* CHECK dout0_0 vdout0_0ck32 = 0 time = 330
* CHECK dout0_1 vdout0_1ck32 = 3.3 time = 330
* CHECK dout0_0 vdout0_0ck33 = 3.3 time = 340
* CHECK dout0_1 vdout0_1ck33 = 3.3 time = 340
* CHECK dout0_0 vdout0_0ck35 = 3.3 time = 360
* CHECK dout0_1 vdout0_1ck35 = 3.3 time = 360
* CHECK dout0_0 vdout0_0ck36 = 0 time = 370
* CHECK dout0_1 vdout0_1ck36 = 3.3 time = 370
* CHECK dout0_0 vdout0_0ck40 = 0 time = 410
* CHECK dout0_1 vdout0_1ck40 = 3.3 time = 410
* CHECK dout0_0 vdout0_0ck45 = 0 time = 460
* CHECK dout0_1 vdout0_1ck45 = 3.3 time = 460
* CHECK dout0_0 vdout0_0ck46 = 3.3 time = 470
* CHECK dout0_1 vdout0_1ck46 = 0 time = 470
* CHECK dout0_0 vdout0_0ck47 = 0 time = 480
* CHECK dout0_1 vdout0_1ck47 = 3.3 time = 480
* CHECK dout0_0 vdout0_0ck48 = 0 time = 490
* CHECK dout0_1 vdout0_1ck48 = 3.3 time = 490
* CHECK dout0_0 vdout0_0ck49 = 3.3 time = 500
* CHECK dout0_1 vdout0_1ck49 = 0 time = 500
* CHECK dout0_0 vdout0_0ck50 = 0 time = 510
* CHECK dout0_1 vdout0_1ck50 = 3.3 time = 510
* CHECK dout0_0 vdout0_0ck52 = 0 time = 530
* CHECK dout0_1 vdout0_1ck52 = 3.3 time = 530
* CHECK dout0_0 vdout0_0ck53 = 0 time = 540
* CHECK dout0_1 vdout0_1ck53 = 3.3 time = 540
* CHECK dout0_0 vdout0_0ck65 = 0 time = 660
* CHECK dout0_1 vdout0_1ck65 = 3.3 time = 660
* CHECK dout0_0 vdout0_0ck66 = 0 time = 670
* CHECK dout0_1 vdout0_1ck66 = 3.3 time = 670
* CHECK dout0_0 vdout0_0ck71 = 0 time = 720
* CHECK dout0_1 vdout0_1ck71 = 3.3 time = 720
* CHECK dout0_0 vdout0_0ck73 = 0 time = 740
* CHECK dout0_1 vdout0_1ck73 = 3.3 time = 740
* CHECK dout0_0 vdout0_0ck74 = 3.3 time = 750
* CHECK dout0_1 vdout0_1ck74 = 3.3 time = 750
* CHECK dout0_0 vdout0_0ck75 = 3.3 time = 760
* CHECK dout0_1 vdout0_1ck75 = 3.3 time = 760
* CHECK dout0_0 vdout0_0ck76 = 0 time = 770
* CHECK dout0_1 vdout0_1ck76 = 3.3 time = 770
* CHECK dout0_0 vdout0_0ck81 = 3.3 time = 820
* CHECK dout0_1 vdout0_1ck81 = 3.3 time = 820
* CHECK dout0_0 vdout0_0ck82 = 3.3 time = 830
* CHECK dout0_1 vdout0_1ck82 = 3.3 time = 830
* CHECK dout0_0 vdout0_0ck85 = 3.3 time = 860
* CHECK dout0_1 vdout0_1ck85 = 3.3 time = 860
* CHECK dout0_0 vdout0_0ck86 = 3.3 time = 870
* CHECK dout0_1 vdout0_1ck86 = 3.3 time = 870
* CHECK dout0_0 vdout0_0ck88 = 3.3 time = 890
* CHECK dout0_1 vdout0_1ck88 = 3.3 time = 890
* CHECK dout0_0 vdout0_0ck89 = 3.3 time = 900
* CHECK dout0_1 vdout0_1ck89 = 3.3 time = 900
* CHECK dout0_0 vdout0_0ck92 = 3.3 time = 930
* CHECK dout0_1 vdout0_1ck92 = 3.3 time = 930
* CHECK dout0_0 vdout0_0ck93 = 3.3 time = 940
* CHECK dout0_1 vdout0_1ck93 = 3.3 time = 940
* CHECK dout0_0 vdout0_0ck95 = 3.3 time = 960
* CHECK dout0_1 vdout0_1ck95 = 3.3 time = 960
* CHECK dout0_0 vdout0_0ck96 = 0 time = 970
* CHECK dout0_1 vdout0_1ck96 = 3.3 time = 970
* CHECK dout0_0 vdout0_0ck97 = 3.3 time = 980
* CHECK dout0_1 vdout0_1ck97 = 3.3 time = 980
* CHECK dout0_0 vdout0_0ck99 = 3.3 time = 1000
* CHECK dout0_1 vdout0_1ck99 = 0 time = 1000
* CHECK dout0_0 vdout0_0ck101 = 3.3 time = 1020
* CHECK dout0_1 vdout0_1ck101 = 0 time = 1020
* CHECK dout0_0 vdout0_0ck107 = 0 time = 1080
* CHECK dout0_1 vdout0_1ck107 = 3.3 time = 1080
* CHECK dout0_0 vdout0_0ck109 = 0 time = 1100
* CHECK dout0_1 vdout0_1ck109 = 3.3 time = 1100
* CHECK dout0_0 vdout0_0ck110 = 0 time = 1110
* CHECK dout0_1 vdout0_1ck110 = 3.3 time = 1110
* CHECK dout0_0 vdout0_0ck111 = 0 time = 1120
* CHECK dout0_1 vdout0_1ck111 = 3.3 time = 1120
* CHECK dout0_0 vdout0_0ck119 = 3.3 time = 1200
* CHECK dout0_1 vdout0_1ck119 = 0 time = 1200
* CHECK dout0_0 vdout0_0ck120 = 3.3 time = 1210
* CHECK dout0_1 vdout0_1ck120 = 0 time = 1210
* CHECK dout0_0 vdout0_0ck121 = 3.3 time = 1220
* CHECK dout0_1 vdout0_1ck121 = 0 time = 1220
* CHECK dout0_0 vdout0_0ck122 = 3.3 time = 1230
* CHECK dout0_1 vdout0_1ck122 = 3.3 time = 1230
* CHECK dout0_0 vdout0_0ck123 = 3.3 time = 1240
* CHECK dout0_1 vdout0_1ck123 = 0 time = 1240
* CHECK dout0_0 vdout0_0ck125 = 3.3 time = 1260
* CHECK dout0_1 vdout0_1ck125 = 0 time = 1260
* CHECK dout0_0 vdout0_0ck126 = 3.3 time = 1270
* CHECK dout0_1 vdout0_1ck126 = 3.3 time = 1270
* CHECK dout0_0 vdout0_0ck127 = 3.3 time = 1280
* CHECK dout0_1 vdout0_1ck127 = 0 time = 1280
* CHECK dout0_0 vdout0_0ck131 = 3.3 time = 1320
* CHECK dout0_1 vdout0_1ck131 = 3.3 time = 1320
* CHECK dout0_0 vdout0_0ck135 = 0 time = 1360
* CHECK dout0_1 vdout0_1ck135 = 3.3 time = 1360
* CHECK dout0_0 vdout0_0ck136 = 3.3 time = 1370
* CHECK dout0_1 vdout0_1ck136 = 3.3 time = 1370
* CHECK dout0_0 vdout0_0ck139 = 0 time = 1400
* CHECK dout0_1 vdout0_1ck139 = 3.3 time = 1400
* CHECK dout0_0 vdout0_0ck147 = 3.3 time = 1480
* CHECK dout0_1 vdout0_1ck147 = 0 time = 1480
* CHECK dout0_0 vdout0_0ck151 = 3.3 time = 1520
* CHECK dout0_1 vdout0_1ck151 = 3.3 time = 1520
* CHECK dout0_0 vdout0_0ck152 = 3.3 time = 1530
* CHECK dout0_1 vdout0_1ck152 = 3.3 time = 1530
* CHECK dout0_0 vdout0_0ck153 = 3.3 time = 1540
* CHECK dout0_1 vdout0_1ck153 = 3.3 time = 1540
* CHECK dout0_0 vdout0_0ck156 = 3.3 time = 1570
* CHECK dout0_1 vdout0_1ck156 = 3.3 time = 1570
* CHECK dout0_0 vdout0_0ck158 = 0 time = 1590
* CHECK dout0_1 vdout0_1ck158 = 3.3 time = 1590
* CHECK dout0_0 vdout0_0ck161 = 0 time = 1620
* CHECK dout0_1 vdout0_1ck161 = 3.3 time = 1620
* CHECK dout0_0 vdout0_0ck163 = 0 time = 1640
* CHECK dout0_1 vdout0_1ck163 = 3.3 time = 1640
* CHECK dout0_0 vdout0_0ck164 = 0 time = 1650
* CHECK dout0_1 vdout0_1ck164 = 3.3 time = 1650
* CHECK dout0_0 vdout0_0ck165 = 0 time = 1660
* CHECK dout0_1 vdout0_1ck165 = 3.3 time = 1660
* CHECK dout0_0 vdout0_0ck168 = 3.3 time = 1690
* CHECK dout0_1 vdout0_1ck168 = 0 time = 1690
* CHECK dout0_0 vdout0_0ck169 = 3.3 time = 1700
* CHECK dout0_1 vdout0_1ck169 = 0 time = 1700
* CHECK dout0_0 vdout0_0ck170 = 3.3 time = 1710
* CHECK dout0_1 vdout0_1ck170 = 0 time = 1710
* CHECK dout0_0 vdout0_0ck171 = 3.3 time = 1720
* CHECK dout0_1 vdout0_1ck171 = 0 time = 1720
* CHECK dout0_0 vdout0_0ck172 = 3.3 time = 1730
* CHECK dout0_1 vdout0_1ck172 = 0 time = 1730
* CHECK dout0_0 vdout0_0ck173 = 3.3 time = 1740
* CHECK dout0_1 vdout0_1ck173 = 0 time = 1740
* CHECK dout0_0 vdout0_0ck175 = 3.3 time = 1760
* CHECK dout0_1 vdout0_1ck175 = 0 time = 1760
* CHECK dout0_0 vdout0_0ck176 = 3.3 time = 1770
* CHECK dout0_1 vdout0_1ck176 = 0 time = 1770
* CHECK dout0_0 vdout0_0ck179 = 3.3 time = 1800
* CHECK dout0_1 vdout0_1ck179 = 0 time = 1800
* CHECK dout0_0 vdout0_0ck180 = 3.3 time = 1810
* CHECK dout0_1 vdout0_1ck180 = 0 time = 1810
* CHECK dout0_0 vdout0_0ck181 = 3.3 time = 1820
* CHECK dout0_1 vdout0_1ck181 = 0 time = 1820
* CHECK dout0_0 vdout0_0ck183 = 3.3 time = 1840
* CHECK dout0_1 vdout0_1ck183 = 0 time = 1840
* CHECK dout0_0 vdout0_0ck184 = 3.3 time = 1850
* CHECK dout0_1 vdout0_1ck184 = 0 time = 1850
* CHECK dout0_0 vdout0_0ck187 = 0 time = 1880
* CHECK dout0_1 vdout0_1ck187 = 3.3 time = 1880
* CHECK dout0_0 vdout0_0ck190 = 0 time = 1910
* CHECK dout0_1 vdout0_1ck190 = 3.3 time = 1910
* CHECK dout0_0 vdout0_0ck193 = 3.3 time = 1940
* CHECK dout0_1 vdout0_1ck193 = 0 time = 1940
* CHECK dout0_0 vdout0_0ck195 = 3.3 time = 1960
* CHECK dout0_1 vdout0_1ck195 = 0 time = 1960
* CHECK dout0_0 vdout0_0ck196 = 0 time = 1970
* CHECK dout0_1 vdout0_1ck196 = 3.3 time = 1970
* CHECK dout0_0 vdout0_0ck197 = 0 time = 1980
* CHECK dout0_1 vdout0_1ck197 = 3.3 time = 1980
* CHECK dout0_0 vdout0_0ck198 = 3.3 time = 1990
* CHECK dout0_1 vdout0_1ck198 = 0 time = 1990
* CHECK dout0_0 vdout0_0ck199 = 0 time = 2000
* CHECK dout0_1 vdout0_1ck199 = 3.3 time = 2000
* CHECK dout0_0 vdout0_0ck200 = 3.3 time = 2010
* CHECK dout0_1 vdout0_1ck200 = 0 time = 2010
* CHECK dout0_0 vdout0_0ck201 = 0 time = 2020
* CHECK dout0_1 vdout0_1ck201 = 3.3 time = 2020
* CHECK dout0_0 vdout0_0ck204 = 3.3 time = 2050
* CHECK dout0_1 vdout0_1ck204 = 3.3 time = 2050
.include /Users/stanlee/OpenRAM/temp/functional_meas.sp
* probe is used for hspice/xa, while plot is used in ngspice
*.probe V(*)
*.plot V(*)
.end
